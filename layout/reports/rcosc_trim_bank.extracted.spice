* extracted by klt extract --deck gf180mcu

* cell rcosc_trim_bank
* pin m
* pin p
* pin t0
* pin t1
* pin t2
* pin t3
* pin t4
* pin t5
* pin t6
* pin t7
* pin vdd
* pin vss
.SUBCKT rcosc_trim_bank m p t0 t1 t2 t3 t4 t5 t6 t7 vdd vss
* device instance $1 r0 *1 33.416,1 nfet
M$1 \$10 t0 vss vsubs nfet L=0.5U W=2U AS=0.84P AD=0.84P PS=4.84U PD=4.84U
* device instance $2 r0 *1 50.213,1 nfet
M$2 \$12 t1 vss vsubs nfet L=0.5U W=2U AS=0.84P AD=0.84P PS=4.84U PD=4.84U
* device instance $3 r0 *1 68.506,1 nfet
M$3 \$14 t2 vss vsubs nfet L=0.5U W=2U AS=0.84P AD=0.84P PS=4.84U PD=4.84U
* device instance $4 r0 *1 89.792,1 nfet
M$4 \$16 t3 vss vsubs nfet L=0.5U W=2U AS=0.84P AD=0.84P PS=4.84U PD=4.84U
* device instance $5 r0 *1 117.064,1 nfet
M$5 \$18 t4 vss vsubs nfet L=0.5U W=2U AS=0.84P AD=0.84P PS=4.84U PD=4.84U
* device instance $6 r0 *1 156.308,1 nfet
M$6 \$20 t5 vss vsubs nfet L=0.5U W=2U AS=0.84P AD=0.84P PS=4.84U PD=4.84U
* device instance $7 r0 *1 219.496,1 nfet
M$7 \$22 t6 vss vsubs nfet L=0.5U W=2U AS=0.84P AD=0.84P PS=4.84U PD=4.84U
* device instance $8 r0 *1 330.571,1 nfet
M$8 \$24 t7 vss vsubs nfet L=0.5U W=2U AS=0.84P AD=0.84P PS=4.84U PD=4.84U
* device instance $9 r0 *1 325.341,1.5 nfet
M$9 \$21 t7 m vsubs nfet L=0.28U W=3U AS=1.26P AD=1.26P PS=6.84U PD=6.84U
* device instance $10 r0 *1 214.266,2 nfet
M$10 \$19 t6 \$21 vsubs nfet L=0.28U W=4U AS=1.68P AD=1.68P PS=8.84U PD=8.84U
* device instance $11 r0 *1 151.078,2.5 nfet
M$11 \$17 t5 \$19 vsubs nfet L=0.28U W=5U AS=2.1P AD=2.1P PS=10.84U PD=10.84U
* device instance $12 r0 *1 111.834,3 nfet
M$12 \$15 t4 \$17 vsubs nfet L=0.28U W=6U AS=2.52P AD=2.52P PS=12.84U PD=12.84U
* device instance $13 r0 *1 84.562,4 nfet
M$13 \$13 t3 \$15 vsubs nfet L=0.28U W=8U AS=3.36P AD=3.36P PS=16.84U PD=16.84U
* device instance $14 r0 *1 63.276,6 nfet
M$14 \$11 t2 \$13 vsubs nfet L=0.28U W=12U AS=5.04P AD=5.04P PS=24.84U PD=24.84U
* device instance $15 r0 *1 44.983,8 nfet
M$15 \$8 t1 \$11 vsubs nfet L=0.28U W=16U AS=6.72P AD=6.72P PS=32.84U PD=32.84U
* device instance $16 r0 *1 28.186,12 nfet
M$16 \$7 t0 \$8 vsubs nfet L=0.28U W=24U AS=10.08P AD=10.08P PS=48.84U PD=48.84U
* device instance $17 r0 *1 373.891,1.5 pfet
M$17 m \$24 \$21 vdd pfet L=0.28U W=3U AS=1.26P AD=1.26P PS=6.84U PD=6.84U
* device instance $18 r0 *1 368.471,2 pfet
M$18 \$21 \$22 \$19 vdd pfet L=0.28U W=4U AS=1.68P AD=1.68P PS=8.84U PD=8.84U
* device instance $19 r0 *1 379.421,2 pfet
M$19 \$10 t0 vdd vdd pfet L=0.5U W=4U AS=1.68P AD=1.68P PS=8.84U PD=8.84U
* device instance $20 r0 *1 385.061,2 pfet
M$20 \$12 t1 vdd vdd pfet L=0.5U W=4U AS=1.68P AD=1.68P PS=8.84U PD=8.84U
* device instance $21 r0 *1 390.701,2 pfet
M$21 \$14 t2 vdd vdd pfet L=0.5U W=4U AS=1.68P AD=1.68P PS=8.84U PD=8.84U
* device instance $22 r0 *1 396.341,2 pfet
M$22 \$16 t3 vdd vdd pfet L=0.5U W=4U AS=1.68P AD=1.68P PS=8.84U PD=8.84U
* device instance $23 r0 *1 401.981,2 pfet
M$23 \$18 t4 vdd vdd pfet L=0.5U W=4U AS=1.68P AD=1.68P PS=8.84U PD=8.84U
* device instance $24 r0 *1 407.621,2 pfet
M$24 \$20 t5 vdd vdd pfet L=0.5U W=4U AS=1.68P AD=1.68P PS=8.84U PD=8.84U
* device instance $25 r0 *1 413.261,2 pfet
M$25 \$22 t6 vdd vdd pfet L=0.5U W=4U AS=1.68P AD=1.68P PS=8.84U PD=8.84U
* device instance $26 r0 *1 418.901,2 pfet
M$26 \$24 t7 vdd vdd pfet L=0.5U W=4U AS=1.68P AD=1.68P PS=8.84U PD=8.84U
* device instance $27 r0 *1 363.051,2.5 pfet
M$27 \$19 \$20 \$17 vdd pfet L=0.28U W=5U AS=2.1P AD=2.1P PS=10.84U PD=10.84U
* device instance $28 r0 *1 357.631,3 pfet
M$28 \$17 \$18 \$15 vdd pfet L=0.28U W=6U AS=2.52P AD=2.52P PS=12.84U PD=12.84U
* device instance $29 r0 *1 352.211,4 pfet
M$29 \$15 \$16 \$13 vdd pfet L=0.28U W=8U AS=3.36P AD=3.36P PS=16.84U PD=16.84U
* device instance $30 r0 *1 346.791,6 pfet
M$30 \$13 \$14 \$11 vdd pfet L=0.28U W=12U AS=5.04P AD=5.04P PS=24.84U PD=24.84U
* device instance $31 r0 *1 341.371,8 pfet
M$31 \$11 \$12 \$8 vdd pfet L=0.28U W=16U AS=6.72P AD=6.72P PS=32.84U PD=32.84U
* device instance $32 r0 *1 335.951,12 pfet
M$32 \$8 \$10 \$7 vdd pfet L=0.28U W=24U AS=10.08P AD=10.08P PS=48.84U PD=48.84U
* device instance $33 r0 *1 9.019,1 ppolyf_u_1k
R$33 p \$7 vsubs 8599 ppolyf_u_1k
* device instance $34 r0 *1 22.832,1 ppolyf_u_1k
R$34 \$7 \$8 vsubs 374 ppolyf_u_1k
* device instance $35 r0 *1 39.254,1 ppolyf_u_1k
R$35 \$8 \$11 vsubs 748.5 ppolyf_u_1k
* device instance $36 r0 *1 56.799,1 ppolyf_u_1k
R$36 \$11 \$13 vsubs 1496.5 ppolyf_u_1k
* device instance $37 r0 *1 76.589,1 ppolyf_u_1k
R$37 \$13 \$15 vsubs 2993 ppolyf_u_1k
* device instance $38 r0 *1 100.868,1 ppolyf_u_1k
R$38 \$15 \$17 vsubs 5986 ppolyf_u_1k
* device instance $39 r0 *1 134.126,1 ppolyf_u_1k
R$39 \$17 \$19 vsubs 11972 ppolyf_u_1k
* device instance $40 r0 *1 185.342,1 ppolyf_u_1k
R$40 \$19 \$21 vsubs 23944 ppolyf_u_1k
* device instance $41 r0 *1 272.473,1 ppolyf_u_1k
R$41 \$21 m vsubs 47887.5 ppolyf_u_1k
.ENDS rcosc_trim_bank
