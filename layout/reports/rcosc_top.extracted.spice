* extracted by klt extract --deck gf180mcu

* cell rcosc_top
* pin clk
* pin t0
* pin t1
* pin t2
* pin t3
* pin t4
* pin t5
* pin t6
* pin t7
* pin vdd
* pin vss
.SUBCKT rcosc_top clk t0 t1 t2 t3 t4 t5 t6 t7 vdd vss
* device instance $1 r0 *1 317.05,1 nfet
M$1 \$18 \$18 vss vsubs nfet L=1U W=2U AS=0.84P AD=0.84P PS=4.84U PD=4.84U
* device instance $2 r0 *1 385.01,1 nfet
M$2 \$19 \$12 vss vsubs nfet L=20U W=2U AS=0.84P AD=0.84P PS=4.84U PD=4.84U
* device instance $3 r0 *1 687.971,2 nfet
M$3 \$29 \$14 \$28 vsubs nfet L=0.5U W=4U AS=1.68P AD=1.68P PS=8.84U PD=8.84U
* device instance $4 r0 *1 693.311,2 nfet
M$4 \$30 \$11 \$28 vsubs nfet L=0.5U W=4U AS=1.68P AD=1.68P PS=8.84U PD=8.84U
* device instance $5 r0 *1 698.651,1 nfet
M$5 \$15 \$29 vss vsubs nfet L=0.5U W=2U AS=0.84P AD=0.84P PS=4.84U PD=4.84U
* device instance $6 r0 *1 745.941,2 nfet
M$6 \$32 \$12 \$31 vsubs nfet L=0.5U W=4U AS=1.68P AD=1.68P PS=8.84U PD=8.84U
* device instance $7 r0 *1 751.281,2 nfet
M$7 \$33 \$14 \$31 vsubs nfet L=0.5U W=4U AS=1.68P AD=1.68P PS=8.84U PD=8.84U
* device instance $8 r0 *1 756.621,1 nfet
M$8 \$16 \$32 vss vsubs nfet L=0.5U W=2U AS=0.84P AD=0.84P PS=4.84U PD=4.84U
* device instance $9 r0 *1 786.521,10 nfet
M$9 \$14 clk vss vsubs nfet L=0.5U W=20U AS=8.4P AD=8.4P PS=40.84U PD=40.84U
* device instance $10 r0 *1 791.861,1 nfet
M$10 \$17 \$15 vss vsubs nfet L=0.5U W=2U AS=0.84P AD=0.84P PS=4.84U PD=4.84U
* device instance $11 r0 *1 797.201,1 nfet
M$11 \$17 clk vss vsubs nfet L=0.5U W=2U AS=0.84P AD=0.84P PS=4.84U PD=4.84U
* device instance $12 r0 *1 802.541,1 nfet
M$12 clk \$16 vss vsubs nfet L=0.5U W=2U AS=0.84P AD=0.84P PS=4.84U PD=4.84U
* device instance $13 r0 *1 807.881,1 nfet
M$13 clk \$17 vss vsubs nfet L=0.5U W=2U AS=0.84P AD=0.84P PS=4.84U PD=4.84U
* device instance $14 r0 *1 322.89,1.82 nfet
M$14 \$19 \$18 \$1 vsubs nfet L=1U W=2U AS=0.84P AD=0.42P PS=4.84U PD=2.42U
* device instance $15 r0 *1 324.31,1.82 nfet
M$15 \$1 \$18 \$19 vsubs nfet L=1U W=2U AS=0.42P AD=0.42P PS=2.42U PD=2.42U
* device instance $16 r0 *1 325.73,1.82 nfet
M$16 \$19 \$18 \$1 vsubs nfet L=1U W=2U AS=0.42P AD=0.42P PS=2.42U PD=2.42U
* device instance $17 r0 *1 327.15,1.82 nfet
M$17 \$1 \$18 \$19 vsubs nfet L=1U W=2U AS=0.42P AD=0.42P PS=2.42U PD=2.42U
* device instance $18 r0 *1 328.57,1.82 nfet
M$18 \$19 \$18 \$1 vsubs nfet L=1U W=2U AS=0.42P AD=0.42P PS=2.42U PD=2.42U
* device instance $19 r0 *1 329.99,1.82 nfet
M$19 \$1 \$18 \$19 vsubs nfet L=1U W=2U AS=0.42P AD=0.42P PS=2.42U PD=2.42U
* device instance $20 r0 *1 331.41,1.82 nfet
M$20 \$19 \$18 \$1 vsubs nfet L=1U W=2U AS=0.42P AD=0.42P PS=2.42U PD=2.42U
* device instance $21 r0 *1 332.83,1.82 nfet
M$21 \$1 \$18 \$19 vsubs nfet L=1U W=2U AS=0.42P AD=0.84P PS=2.42U PD=4.84U
* device instance $22 r0 *1 672.441,1.82 nfet
M$22 \$28 \$18 vss vsubs nfet L=1U W=2U AS=0.84P AD=0.42P PS=4.84U PD=2.42U
* device instance $23 r0 *1 673.861,1.82 nfet
M$23 vss \$18 \$28 vsubs nfet L=1U W=2U AS=0.42P AD=0.42P PS=2.42U PD=2.42U
* device instance $24 r0 *1 675.281,1.82 nfet
M$24 \$28 \$18 vss vsubs nfet L=1U W=2U AS=0.42P AD=0.42P PS=2.42U PD=2.42U
* device instance $25 r0 *1 676.701,1.82 nfet
M$25 vss \$18 \$28 vsubs nfet L=1U W=2U AS=0.42P AD=0.42P PS=2.42U PD=2.42U
* device instance $26 r0 *1 678.121,1.82 nfet
M$26 \$28 \$18 vss vsubs nfet L=1U W=2U AS=0.42P AD=0.42P PS=2.42U PD=2.42U
* device instance $27 r0 *1 679.541,1.82 nfet
M$27 vss \$18 \$28 vsubs nfet L=1U W=2U AS=0.42P AD=0.42P PS=2.42U PD=2.42U
* device instance $28 r0 *1 680.961,1.82 nfet
M$28 \$28 \$18 vss vsubs nfet L=1U W=2U AS=0.42P AD=0.42P PS=2.42U PD=2.42U
* device instance $29 r0 *1 682.381,1.82 nfet
M$29 vss \$18 \$28 vsubs nfet L=1U W=2U AS=0.42P AD=0.84P PS=2.42U PD=4.84U
* device instance $30 r0 *1 730.411,1.82 nfet
M$30 \$31 \$18 vss vsubs nfet L=1U W=2U AS=0.84P AD=0.42P PS=4.84U PD=2.42U
* device instance $31 r0 *1 731.831,1.82 nfet
M$31 vss \$18 \$31 vsubs nfet L=1U W=2U AS=0.42P AD=0.42P PS=2.42U PD=2.42U
* device instance $32 r0 *1 733.251,1.82 nfet
M$32 \$31 \$18 vss vsubs nfet L=1U W=2U AS=0.42P AD=0.42P PS=2.42U PD=2.42U
* device instance $33 r0 *1 734.671,1.82 nfet
M$33 vss \$18 \$31 vsubs nfet L=1U W=2U AS=0.42P AD=0.42P PS=2.42U PD=2.42U
* device instance $34 r0 *1 736.091,1.82 nfet
M$34 \$31 \$18 vss vsubs nfet L=1U W=2U AS=0.42P AD=0.42P PS=2.42U PD=2.42U
* device instance $35 r0 *1 737.511,1.82 nfet
M$35 vss \$18 \$31 vsubs nfet L=1U W=2U AS=0.42P AD=0.42P PS=2.42U PD=2.42U
* device instance $36 r0 *1 738.931,1.82 nfet
M$36 \$31 \$18 vss vsubs nfet L=1U W=2U AS=0.42P AD=0.42P PS=2.42U PD=2.42U
* device instance $37 r0 *1 740.351,1.82 nfet
M$37 vss \$18 \$31 vsubs nfet L=1U W=2U AS=0.42P AD=0.84P PS=2.42U PD=4.84U
* device instance $38 r0 *1 441.182,7 nfet
M$38 \$3 t0 \$2 vsubs nfet L=0.5U W=4U AS=1.68P AD=1.68P PS=8.84U PD=8.84U
* device instance $39 r0 *1 447.144,7 nfet
M$39 \$4 t1 \$3 vsubs nfet L=0.5U W=4U AS=1.68P AD=1.68P PS=8.84U PD=8.84U
* device instance $40 r0 *1 454.23,7 nfet
M$40 \$5 t2 \$4 vsubs nfet L=0.5U W=4U AS=1.68P AD=1.68P PS=8.84U PD=8.84U
* device instance $41 r0 *1 463.559,7 nfet
M$41 \$6 t3 \$5 vsubs nfet L=0.5U W=4U AS=1.68P AD=1.68P PS=8.84U PD=8.84U
* device instance $42 r0 *1 477.378,7 nfet
M$42 \$7 t4 \$6 vsubs nfet L=0.5U W=4U AS=1.68P AD=1.68P PS=8.84U PD=8.84U
* device instance $43 r0 *1 500.176,7 nfet
M$43 \$8 t5 \$7 vsubs nfet L=0.5U W=4U AS=1.68P AD=1.68P PS=8.84U PD=8.84U
* device instance $44 r0 *1 540.932,7 nfet
M$44 \$9 t6 \$8 vsubs nfet L=0.5U W=4U AS=1.68P AD=1.68P PS=8.84U PD=8.84U
* device instance $45 r0 *1 617.604,7 nfet
M$45 \$14 t7 \$9 vsubs nfet L=0.5U W=4U AS=1.68P AD=1.68P PS=8.84U PD=8.84U
* device instance $46 r0 *1 400.5,2 pfet
M$46 \$19 \$19 vdd vdd pfet L=1U W=4U AS=1.68P AD=1.68P PS=8.84U PD=8.84U
* device instance $47 r0 *1 406.64,2 pfet
M$47 \$18 \$19 vdd vdd pfet L=1U W=4U AS=1.68P AD=1.68P PS=8.84U PD=8.84U
* device instance $48 r0 *1 704.391,2 pfet
M$48 \$30 \$30 vdd vdd pfet L=1U W=4U AS=1.68P AD=1.68P PS=8.84U PD=8.84U
* device instance $49 r0 *1 710.531,2 pfet
M$49 \$29 \$30 vdd vdd pfet L=1U W=4U AS=1.68P AD=1.68P PS=8.84U PD=8.84U
* device instance $50 r0 *1 716.421,2 pfet
M$50 \$15 \$29 vdd vdd pfet L=0.5U W=4U AS=1.68P AD=1.68P PS=8.84U PD=8.84U
* device instance $51 r0 *1 762.361,2 pfet
M$51 \$33 \$33 vdd vdd pfet L=1U W=4U AS=1.68P AD=1.68P PS=8.84U PD=8.84U
* device instance $52 r0 *1 768.501,2 pfet
M$52 \$32 \$33 vdd vdd pfet L=1U W=4U AS=1.68P AD=1.68P PS=8.84U PD=8.84U
* device instance $53 r0 *1 774.391,2 pfet
M$53 \$16 \$32 vdd vdd pfet L=0.5U W=4U AS=1.68P AD=1.68P PS=8.84U PD=8.84U
* device instance $54 r0 *1 813.371,2 pfet
M$54 \$34 \$15 vdd vdd pfet L=0.5U W=4U AS=1.68P AD=1.68P PS=8.84U PD=8.84U
* device instance $55 r0 *1 819.011,2 pfet
M$55 \$17 clk \$34 vdd pfet L=0.5U W=4U AS=1.68P AD=1.68P PS=8.84U PD=8.84U
* device instance $56 r0 *1 824.651,2 pfet
M$56 \$35 \$16 vdd vdd pfet L=0.5U W=4U AS=1.68P AD=1.68P PS=8.84U PD=8.84U
* device instance $57 r0 *1 830.291,2 pfet
M$57 clk \$17 \$35 vdd pfet L=0.5U W=4U AS=1.68P AD=1.68P PS=8.84U PD=8.84U
* device instance $58 r0 *1 852.251,6 cap_mim_1f0_m4m5_noshield
C$58 vss \$14 2.172e-13 cap_mim_1f0_m4m5_noshield
* device instance $59 r0 *1 52.03,1 ppolyf_u_1k
R$59 vdd \$11 vsubs 50000 ppolyf_u_1k
* device instance $60 r0 *1 156.87,1 ppolyf_u_1k
R$60 \$11 \$12 vsubs 50000 ppolyf_u_1k
* device instance $61 r0 *1 261.71,1 ppolyf_u_1k
R$61 \$12 vss vsubs 50000 ppolyf_u_1k
* device instance $62 r0 *1 354.17,1 ppolyf_u_1k
R$62 \$1 vss vsubs 16000 ppolyf_u_1k
* device instance $63 r0 *1 427.369,1 ppolyf_u_1k
R$63 vdd \$2 vsubs 8599 ppolyf_u_1k
* device instance $64 r0 *1 441.182,1 ppolyf_u_1k
R$64 \$2 \$3 vsubs 374 ppolyf_u_1k
* device instance $65 r0 *1 447.144,1 ppolyf_u_1k
R$65 \$3 \$4 vsubs 748.5 ppolyf_u_1k
* device instance $66 r0 *1 454.229,1 ppolyf_u_1k
R$66 \$4 \$5 vsubs 1496.5 ppolyf_u_1k
* device instance $67 r0 *1 463.559,1 ppolyf_u_1k
R$67 \$5 \$6 vsubs 2993 ppolyf_u_1k
* device instance $68 r0 *1 477.378,1 ppolyf_u_1k
R$68 \$6 \$7 vsubs 5986 ppolyf_u_1k
* device instance $69 r0 *1 500.176,1 ppolyf_u_1k
R$69 \$7 \$8 vsubs 11972 ppolyf_u_1k
* device instance $70 r0 *1 540.932,1 ppolyf_u_1k
R$70 \$8 \$9 vsubs 23944 ppolyf_u_1k
* device instance $71 r0 *1 617.603,1 ppolyf_u_1k
R$71 \$9 \$14 vsubs 47887.5 ppolyf_u_1k
.ENDS rcosc_top
