* extracted by klt extract --deck gf180mcu

* cell rcosc_top
* pin clk
* pin t0
* pin t1
* pin t2
* pin t3
* pin t4
* pin t5
* pin t6
* pin t7
* pin vdd
* pin vss
.SUBCKT rcosc_top clk t0 t1 t2 t3 t4 t5 t6 t7 vdd vss
* device instance $1 r0 *1 595.611,1 nfet
M$1 \$15 \$19 vss vsubs nfet L=0.5U W=2U AS=0.84P AD=0.84P PS=4.84U PD=4.84U
* device instance $2 r0 *1 653.581,1 nfet
M$2 \$17 \$22 vss vsubs nfet L=0.5U W=2U AS=0.84P AD=0.84P PS=4.84U PD=4.84U
* device instance $3 r0 *1 688.821,1 nfet
M$3 \$18 \$15 vss vsubs nfet L=0.5U W=2U AS=0.84P AD=0.84P PS=4.84U PD=4.84U
* device instance $4 r0 *1 694.161,1 nfet
M$4 \$18 clk vss vsubs nfet L=0.5U W=2U AS=0.84P AD=0.84P PS=4.84U PD=4.84U
* device instance $5 r0 *1 699.501,1 nfet
M$5 clk \$17 vss vsubs nfet L=0.5U W=2U AS=0.84P AD=0.84P PS=4.84U PD=4.84U
* device instance $6 r0 *1 704.841,1 nfet
M$6 clk \$18 vss vsubs nfet L=0.5U W=2U AS=0.84P AD=0.84P PS=4.84U PD=4.84U
* device instance $7 r0 *1 569.401,1.82 nfet
M$7 \$14 \$13 vss vsubs nfet L=1U W=2U AS=0.84P AD=0.42P PS=4.84U PD=2.42U
* device instance $8 r0 *1 570.821,1.82 nfet
M$8 vss \$13 \$14 vsubs nfet L=1U W=2U AS=0.42P AD=0.42P PS=2.42U PD=2.42U
* device instance $9 r0 *1 572.241,1.82 nfet
M$9 \$14 \$13 vss vsubs nfet L=1U W=2U AS=0.42P AD=0.42P PS=2.42U PD=2.42U
* device instance $10 r0 *1 573.661,1.82 nfet
M$10 vss \$13 \$14 vsubs nfet L=1U W=2U AS=0.42P AD=0.42P PS=2.42U PD=2.42U
* device instance $11 r0 *1 575.081,1.82 nfet
M$11 \$14 \$13 vss vsubs nfet L=1U W=2U AS=0.42P AD=0.42P PS=2.42U PD=2.42U
* device instance $12 r0 *1 576.501,1.82 nfet
M$12 vss \$13 \$14 vsubs nfet L=1U W=2U AS=0.42P AD=0.42P PS=2.42U PD=2.42U
* device instance $13 r0 *1 577.921,1.82 nfet
M$13 \$14 \$13 vss vsubs nfet L=1U W=2U AS=0.42P AD=0.42P PS=2.42U PD=2.42U
* device instance $14 r0 *1 579.341,1.82 nfet
M$14 vss \$13 \$14 vsubs nfet L=1U W=2U AS=0.42P AD=0.84P PS=2.42U PD=4.84U
* device instance $15 r0 *1 627.371,1.82 nfet
M$15 \$16 \$13 vss vsubs nfet L=1U W=2U AS=0.84P AD=0.42P PS=4.84U PD=2.42U
* device instance $16 r0 *1 628.791,1.82 nfet
M$16 vss \$13 \$16 vsubs nfet L=1U W=2U AS=0.42P AD=0.42P PS=2.42U PD=2.42U
* device instance $17 r0 *1 630.211,1.82 nfet
M$17 \$16 \$13 vss vsubs nfet L=1U W=2U AS=0.42P AD=0.42P PS=2.42U PD=2.42U
* device instance $18 r0 *1 631.631,1.82 nfet
M$18 vss \$13 \$16 vsubs nfet L=1U W=2U AS=0.42P AD=0.42P PS=2.42U PD=2.42U
* device instance $19 r0 *1 633.051,1.82 nfet
M$19 \$16 \$13 vss vsubs nfet L=1U W=2U AS=0.42P AD=0.42P PS=2.42U PD=2.42U
* device instance $20 r0 *1 634.471,1.82 nfet
M$20 vss \$13 \$16 vsubs nfet L=1U W=2U AS=0.42P AD=0.42P PS=2.42U PD=2.42U
* device instance $21 r0 *1 635.891,1.82 nfet
M$21 \$16 \$13 vss vsubs nfet L=1U W=2U AS=0.42P AD=0.42P PS=2.42U PD=2.42U
* device instance $22 r0 *1 637.311,1.82 nfet
M$22 vss \$13 \$16 vsubs nfet L=1U W=2U AS=0.42P AD=0.84P PS=2.42U PD=4.84U
* device instance $23 r0 *1 584.931,2 nfet
M$23 \$19 \$12 \$14 vsubs nfet L=0.5U W=4U AS=1.68P AD=1.68P PS=8.84U PD=8.84U
* device instance $24 r0 *1 590.271,2 nfet
M$24 \$20 \$10 \$14 vsubs nfet L=0.5U W=4U AS=1.68P AD=1.68P PS=8.84U PD=8.84U
* device instance $25 r0 *1 642.901,2 nfet
M$25 \$22 \$11 \$16 vsubs nfet L=0.5U W=4U AS=1.68P AD=1.68P PS=8.84U PD=8.84U
* device instance $26 r0 *1 648.241,2 nfet
M$26 \$23 \$12 \$16 vsubs nfet L=0.5U W=4U AS=1.68P AD=1.68P PS=8.84U PD=8.84U
* device instance $27 r0 *1 216.55,7 nfet
M$27 vss \$13 \$13 vsubs nfet L=1U W=2U AS=0.84P AD=0.84P PS=4.84U PD=4.84U
* device instance $28 r0 *1 338.142,7 nfet
M$28 \$2 t0 \$1 vsubs nfet L=0.5U W=4U AS=1.68P AD=1.68P PS=8.84U PD=8.84U
* device instance $29 r0 *1 344.104,7 nfet
M$29 \$3 t1 \$2 vsubs nfet L=0.5U W=4U AS=1.68P AD=1.68P PS=8.84U PD=8.84U
* device instance $30 r0 *1 351.19,7 nfet
M$30 \$4 t2 \$3 vsubs nfet L=0.5U W=4U AS=1.68P AD=1.68P PS=8.84U PD=8.84U
* device instance $31 r0 *1 360.519,7 nfet
M$31 \$5 t3 \$4 vsubs nfet L=0.5U W=4U AS=1.68P AD=1.68P PS=8.84U PD=8.84U
* device instance $32 r0 *1 374.338,7 nfet
M$32 \$6 t4 \$5 vsubs nfet L=0.5U W=4U AS=1.68P AD=1.68P PS=8.84U PD=8.84U
* device instance $33 r0 *1 397.136,7 nfet
M$33 \$7 t5 \$6 vsubs nfet L=0.5U W=4U AS=1.68P AD=1.68P PS=8.84U PD=8.84U
* device instance $34 r0 *1 437.892,7 nfet
M$34 \$8 t6 \$7 vsubs nfet L=0.5U W=4U AS=1.68P AD=1.68P PS=8.84U PD=8.84U
* device instance $35 r0 *1 514.564,7 nfet
M$35 \$12 t7 \$8 vsubs nfet L=0.5U W=4U AS=1.68P AD=1.68P PS=8.84U PD=8.84U
* device instance $36 r0 *1 683.481,10 nfet
M$36 \$12 clk vss vsubs nfet L=0.5U W=20U AS=8.4P AD=8.4P PS=40.84U PD=40.84U
* device instance $37 r0 *1 601.351,2 pfet
M$37 \$20 \$20 vdd vdd pfet L=1U W=4U AS=1.68P AD=1.68P PS=8.84U PD=8.84U
* device instance $38 r0 *1 607.491,2 pfet
M$38 \$19 \$20 vdd vdd pfet L=1U W=4U AS=1.68P AD=1.68P PS=8.84U PD=8.84U
* device instance $39 r0 *1 613.381,2 pfet
M$39 \$15 \$19 vdd vdd pfet L=0.5U W=4U AS=1.68P AD=1.68P PS=8.84U PD=8.84U
* device instance $40 r0 *1 659.321,2 pfet
M$40 \$23 \$23 vdd vdd pfet L=1U W=4U AS=1.68P AD=1.68P PS=8.84U PD=8.84U
* device instance $41 r0 *1 665.461,2 pfet
M$41 \$22 \$23 vdd vdd pfet L=1U W=4U AS=1.68P AD=1.68P PS=8.84U PD=8.84U
* device instance $42 r0 *1 671.351,2 pfet
M$42 \$17 \$22 vdd vdd pfet L=0.5U W=4U AS=1.68P AD=1.68P PS=8.84U PD=8.84U
* device instance $43 r0 *1 710.331,2 pfet
M$43 \$24 \$15 vdd vdd pfet L=0.5U W=4U AS=1.68P AD=1.68P PS=8.84U PD=8.84U
* device instance $44 r0 *1 715.971,2 pfet
M$44 \$18 clk \$24 vdd pfet L=0.5U W=4U AS=1.68P AD=1.68P PS=8.84U PD=8.84U
* device instance $45 r0 *1 721.611,2 pfet
M$45 \$25 \$17 vdd vdd pfet L=0.5U W=4U AS=1.68P AD=1.68P PS=8.84U PD=8.84U
* device instance $46 r0 *1 727.251,2 pfet
M$46 clk \$18 \$25 vdd pfet L=0.5U W=4U AS=1.68P AD=1.68P PS=8.84U PD=8.84U
* device instance $47 r0 *1 749.211,6 cap_mim_1f0_m4m5_noshield
C$47 vss \$12 2.172e-13 cap_mim_1f0_m4m5_noshield
* device instance $48 r0 *1 51.21,1 ppolyf_u_1k
R$48 vdd \$10 vsubs 50000 ppolyf_u_1k
* device instance $49 r0 *1 156.05,1 ppolyf_u_1k
R$49 \$10 \$11 vsubs 50000 ppolyf_u_1k
* device instance $50 r0 *1 260.89,1 ppolyf_u_1k
R$50 \$11 vss vsubs 50000 ppolyf_u_1k
* device instance $51 r0 *1 324.329,1 ppolyf_u_1k
R$51 vdd \$1 vsubs 8599 ppolyf_u_1k
* device instance $52 r0 *1 338.142,1 ppolyf_u_1k
R$52 \$1 \$2 vsubs 374 ppolyf_u_1k
* device instance $53 r0 *1 344.104,1 ppolyf_u_1k
R$53 \$2 \$3 vsubs 748.5 ppolyf_u_1k
* device instance $54 r0 *1 351.189,1 ppolyf_u_1k
R$54 \$3 \$4 vsubs 1496.5 ppolyf_u_1k
* device instance $55 r0 *1 360.519,1 ppolyf_u_1k
R$55 \$4 \$5 vsubs 2993 ppolyf_u_1k
* device instance $56 r0 *1 374.338,1 ppolyf_u_1k
R$56 \$5 \$6 vsubs 5986 ppolyf_u_1k
* device instance $57 r0 *1 397.136,1 ppolyf_u_1k
R$57 \$6 \$7 vsubs 11972 ppolyf_u_1k
* device instance $58 r0 *1 437.892,1 ppolyf_u_1k
R$58 \$7 \$8 vsubs 23944 ppolyf_u_1k
* device instance $59 r0 *1 514.563,1 ppolyf_u_1k
R$59 \$8 \$12 vsubs 47887.5 ppolyf_u_1k
* device instance $60 r0 *1 106.21,7 ppolyf_u_1k
R$60 vdd \$13 vsubs 105000 ppolyf_u_1k
.ENDS rcosc_top
