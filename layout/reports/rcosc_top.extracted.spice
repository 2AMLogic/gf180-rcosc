* extracted by klt extract --deck gf180mcu

* cell rcosc_top
* pin clk
* pin t0
* pin t1
* pin t2
* pin t3
* pin t4
* pin t5
* pin t6
* pin t7
* pin vdd
* pin vss
.SUBCKT rcosc_top clk t0 t1 t2 t3 t4 t5 t6 t7 vdd vss
* device instance $1 r0 *1 317.05,1 nfet
M$1 \$37 \$37 vss vsubs nfet L=1U W=2U AS=0.84P AD=0.84P PS=4.84U PD=4.84U
* device instance $2 r0 *1 385.01,1 nfet
M$2 \$9 \$8 vss vsubs nfet L=20U W=2U AS=0.84P AD=0.84P PS=4.84U PD=4.84U
* device instance $3 r0 *1 448.146,12 nfet
M$3 \$10 t0 \$11 vsubs nfet L=0.28U W=24U AS=10.08P AD=10.08P PS=48.84U
+ PD=48.84U
* device instance $4 r0 *1 453.376,1 nfet
M$4 \$13 t0 vss vsubs nfet L=0.5U W=2U AS=0.84P AD=0.84P PS=4.84U PD=4.84U
* device instance $5 r0 *1 464.943,8 nfet
M$5 \$11 t1 \$14 vsubs nfet L=0.28U W=16U AS=6.72P AD=6.72P PS=32.84U PD=32.84U
* device instance $6 r0 *1 470.173,1 nfet
M$6 \$15 t1 vss vsubs nfet L=0.5U W=2U AS=0.84P AD=0.84P PS=4.84U PD=4.84U
* device instance $7 r0 *1 483.236,6 nfet
M$7 \$14 t2 \$16 vsubs nfet L=0.28U W=12U AS=5.04P AD=5.04P PS=24.84U PD=24.84U
* device instance $8 r0 *1 488.466,1 nfet
M$8 \$17 t2 vss vsubs nfet L=0.5U W=2U AS=0.84P AD=0.84P PS=4.84U PD=4.84U
* device instance $9 r0 *1 504.522,4 nfet
M$9 \$16 t3 \$18 vsubs nfet L=0.28U W=8U AS=3.36P AD=3.36P PS=16.84U PD=16.84U
* device instance $10 r0 *1 509.752,1 nfet
M$10 \$19 t3 vss vsubs nfet L=0.5U W=2U AS=0.84P AD=0.84P PS=4.84U PD=4.84U
* device instance $11 r0 *1 531.794,3 nfet
M$11 \$18 t4 \$20 vsubs nfet L=0.28U W=6U AS=2.52P AD=2.52P PS=12.84U PD=12.84U
* device instance $12 r0 *1 537.024,1 nfet
M$12 \$21 t4 vss vsubs nfet L=0.5U W=2U AS=0.84P AD=0.84P PS=4.84U PD=4.84U
* device instance $13 r0 *1 571.038,2.5 nfet
M$13 \$20 t5 \$22 vsubs nfet L=0.28U W=5U AS=2.1P AD=2.1P PS=10.84U PD=10.84U
* device instance $14 r0 *1 576.268,1 nfet
M$14 \$23 t5 vss vsubs nfet L=0.5U W=2U AS=0.84P AD=0.84P PS=4.84U PD=4.84U
* device instance $15 r0 *1 634.226,2 nfet
M$15 \$22 t6 \$24 vsubs nfet L=0.28U W=4U AS=1.68P AD=1.68P PS=8.84U PD=8.84U
* device instance $16 r0 *1 639.456,1 nfet
M$16 \$25 t6 vss vsubs nfet L=0.5U W=2U AS=0.84P AD=0.84P PS=4.84U PD=4.84U
* device instance $17 r0 *1 745.301,1.5 nfet
M$17 \$24 t7 \$26 vsubs nfet L=0.28U W=3U AS=1.26P AD=1.26P PS=6.84U PD=6.84U
* device instance $18 r0 *1 750.531,1 nfet
M$18 \$27 t7 vss vsubs nfet L=0.5U W=2U AS=0.84P AD=0.84P PS=4.84U PD=4.84U
* device instance $19 r0 *1 868.381,2 nfet
M$19 \$30 \$26 \$29 vsubs nfet L=0.5U W=4U AS=1.68P AD=1.68P PS=8.84U PD=8.84U
* device instance $20 r0 *1 873.721,2 nfet
M$20 \$31 \$7 \$29 vsubs nfet L=0.5U W=4U AS=1.68P AD=1.68P PS=8.84U PD=8.84U
* device instance $21 r0 *1 879.061,1 nfet
M$21 \$32 \$30 vss vsubs nfet L=0.5U W=2U AS=0.84P AD=0.84P PS=4.84U PD=4.84U
* device instance $22 r0 *1 910.821,2 nfet
M$22 \$42 \$42 vss vsubs nfet L=1U W=4U AS=1.68P AD=1.68P PS=8.84U PD=8.84U
* device instance $23 r0 *1 916.661,2 nfet
M$23 \$33 \$42 vss vsubs nfet L=1U W=4U AS=1.68P AD=1.68P PS=8.84U PD=8.84U
* device instance $24 r0 *1 922.251,0.25 nfet
M$24 \$34 \$33 vss vsubs nfet L=0.5U W=0.5U AS=0.21P AD=0.21P PS=1.84U PD=1.84U
* device instance $25 r0 *1 927.591,1 nfet
M$25 \$35 \$34 vss vsubs nfet L=0.5U W=2U AS=0.84P AD=0.84P PS=4.84U PD=4.84U
* device instance $26 r0 *1 978.051,10 nfet
M$26 \$26 clk vss vsubs nfet L=0.5U W=20U AS=8.4P AD=8.4P PS=40.84U PD=40.84U
* device instance $27 r0 *1 983.391,1 nfet
M$27 \$36 \$32 vss vsubs nfet L=0.5U W=2U AS=0.84P AD=0.84P PS=4.84U PD=4.84U
* device instance $28 r0 *1 988.731,1 nfet
M$28 \$36 clk vss vsubs nfet L=0.5U W=2U AS=0.84P AD=0.84P PS=4.84U PD=4.84U
* device instance $29 r0 *1 994.071,1 nfet
M$29 clk \$35 vss vsubs nfet L=0.5U W=2U AS=0.84P AD=0.84P PS=4.84U PD=4.84U
* device instance $30 r0 *1 999.411,1 nfet
M$30 clk \$36 vss vsubs nfet L=0.5U W=2U AS=0.84P AD=0.84P PS=4.84U PD=4.84U
* device instance $31 r0 *1 322.89,1.82 nfet
M$31 \$9 \$37 \$1 vsubs nfet L=1U W=2U AS=0.84P AD=0.42P PS=4.84U PD=2.42U
* device instance $32 r0 *1 324.31,1.82 nfet
M$32 \$1 \$37 \$9 vsubs nfet L=1U W=2U AS=0.42P AD=0.42P PS=2.42U PD=2.42U
* device instance $33 r0 *1 325.73,1.82 nfet
M$33 \$9 \$37 \$1 vsubs nfet L=1U W=2U AS=0.42P AD=0.42P PS=2.42U PD=2.42U
* device instance $34 r0 *1 327.15,1.82 nfet
M$34 \$1 \$37 \$9 vsubs nfet L=1U W=2U AS=0.42P AD=0.42P PS=2.42U PD=2.42U
* device instance $35 r0 *1 328.57,1.82 nfet
M$35 \$9 \$37 \$1 vsubs nfet L=1U W=2U AS=0.42P AD=0.42P PS=2.42U PD=2.42U
* device instance $36 r0 *1 329.99,1.82 nfet
M$36 \$1 \$37 \$9 vsubs nfet L=1U W=2U AS=0.42P AD=0.42P PS=2.42U PD=2.42U
* device instance $37 r0 *1 331.41,1.82 nfet
M$37 \$9 \$37 \$1 vsubs nfet L=1U W=2U AS=0.42P AD=0.42P PS=2.42U PD=2.42U
* device instance $38 r0 *1 332.83,1.82 nfet
M$38 \$1 \$37 \$9 vsubs nfet L=1U W=2U AS=0.42P AD=0.84P PS=2.42U PD=4.84U
* device instance $39 r0 *1 852.851,1.82 nfet
M$39 \$29 \$37 vss vsubs nfet L=1U W=2U AS=0.84P AD=0.42P PS=4.84U PD=2.42U
* device instance $40 r0 *1 854.271,1.82 nfet
M$40 vss \$37 \$29 vsubs nfet L=1U W=2U AS=0.42P AD=0.42P PS=2.42U PD=2.42U
* device instance $41 r0 *1 855.691,1.82 nfet
M$41 \$29 \$37 vss vsubs nfet L=1U W=2U AS=0.42P AD=0.42P PS=2.42U PD=2.42U
* device instance $42 r0 *1 857.111,1.82 nfet
M$42 vss \$37 \$29 vsubs nfet L=1U W=2U AS=0.42P AD=0.42P PS=2.42U PD=2.42U
* device instance $43 r0 *1 858.531,1.82 nfet
M$43 \$29 \$37 vss vsubs nfet L=1U W=2U AS=0.42P AD=0.42P PS=2.42U PD=2.42U
* device instance $44 r0 *1 859.951,1.82 nfet
M$44 vss \$37 \$29 vsubs nfet L=1U W=2U AS=0.42P AD=0.42P PS=2.42U PD=2.42U
* device instance $45 r0 *1 861.371,1.82 nfet
M$45 \$29 \$37 vss vsubs nfet L=1U W=2U AS=0.42P AD=0.42P PS=2.42U PD=2.42U
* device instance $46 r0 *1 862.791,1.82 nfet
M$46 vss \$37 \$29 vsubs nfet L=1U W=2U AS=0.42P AD=0.84P PS=2.42U PD=4.84U
* device instance $47 r0 *1 400.5,2 pfet
M$47 \$9 \$9 vdd vdd pfet L=1U W=4U AS=1.68P AD=1.68P PS=8.84U PD=8.84U
* device instance $48 r0 *1 406.64,2 pfet
M$48 \$37 \$9 vdd vdd pfet L=1U W=4U AS=1.68P AD=1.68P PS=8.84U PD=8.84U
* device instance $49 r0 *1 755.911,12 pfet
M$49 \$11 \$13 \$10 vdd pfet L=0.28U W=24U AS=10.08P AD=10.08P PS=48.84U
+ PD=48.84U
* device instance $50 r0 *1 761.331,8 pfet
M$50 \$14 \$15 \$11 vdd pfet L=0.28U W=16U AS=6.72P AD=6.72P PS=32.84U PD=32.84U
* device instance $51 r0 *1 766.751,6 pfet
M$51 \$16 \$17 \$14 vdd pfet L=0.28U W=12U AS=5.04P AD=5.04P PS=24.84U PD=24.84U
* device instance $52 r0 *1 772.171,4 pfet
M$52 \$18 \$19 \$16 vdd pfet L=0.28U W=8U AS=3.36P AD=3.36P PS=16.84U PD=16.84U
* device instance $53 r0 *1 777.591,3 pfet
M$53 \$20 \$21 \$18 vdd pfet L=0.28U W=6U AS=2.52P AD=2.52P PS=12.84U PD=12.84U
* device instance $54 r0 *1 783.011,2.5 pfet
M$54 \$22 \$23 \$20 vdd pfet L=0.28U W=5U AS=2.1P AD=2.1P PS=10.84U PD=10.84U
* device instance $55 r0 *1 788.431,2 pfet
M$55 \$24 \$25 \$22 vdd pfet L=0.28U W=4U AS=1.68P AD=1.68P PS=8.84U PD=8.84U
* device instance $56 r0 *1 793.851,1.5 pfet
M$56 \$26 \$27 \$24 vdd pfet L=0.28U W=3U AS=1.26P AD=1.26P PS=6.84U PD=6.84U
* device instance $57 r0 *1 799.381,2 pfet
M$57 \$13 t0 vdd vdd pfet L=0.5U W=4U AS=1.68P AD=1.68P PS=8.84U PD=8.84U
* device instance $58 r0 *1 805.021,2 pfet
M$58 \$15 t1 vdd vdd pfet L=0.5U W=4U AS=1.68P AD=1.68P PS=8.84U PD=8.84U
* device instance $59 r0 *1 810.661,2 pfet
M$59 \$17 t2 vdd vdd pfet L=0.5U W=4U AS=1.68P AD=1.68P PS=8.84U PD=8.84U
* device instance $60 r0 *1 816.301,2 pfet
M$60 \$19 t3 vdd vdd pfet L=0.5U W=4U AS=1.68P AD=1.68P PS=8.84U PD=8.84U
* device instance $61 r0 *1 821.941,2 pfet
M$61 \$21 t4 vdd vdd pfet L=0.5U W=4U AS=1.68P AD=1.68P PS=8.84U PD=8.84U
* device instance $62 r0 *1 827.581,2 pfet
M$62 \$23 t5 vdd vdd pfet L=0.5U W=4U AS=1.68P AD=1.68P PS=8.84U PD=8.84U
* device instance $63 r0 *1 833.221,2 pfet
M$63 \$25 t6 vdd vdd pfet L=0.5U W=4U AS=1.68P AD=1.68P PS=8.84U PD=8.84U
* device instance $64 r0 *1 838.861,2 pfet
M$64 \$27 t7 vdd vdd pfet L=0.5U W=4U AS=1.68P AD=1.68P PS=8.84U PD=8.84U
* device instance $65 r0 *1 884.801,2 pfet
M$65 \$31 \$31 vdd vdd pfet L=1U W=4U AS=1.68P AD=1.68P PS=8.84U PD=8.84U
* device instance $66 r0 *1 890.941,2 pfet
M$66 \$30 \$31 vdd vdd pfet L=1U W=4U AS=1.68P AD=1.68P PS=8.84U PD=8.84U
* device instance $67 r0 *1 896.831,2 pfet
M$67 \$32 \$30 vdd vdd pfet L=0.5U W=4U AS=1.68P AD=1.68P PS=8.84U PD=8.84U
* device instance $68 r0 *1 960.281,2 pfet
M$68 \$34 \$33 vdd vdd pfet L=0.5U W=4U AS=1.68P AD=1.68P PS=8.84U PD=8.84U
* device instance $69 r0 *1 965.921,2 pfet
M$69 \$35 \$34 vdd vdd pfet L=0.5U W=4U AS=1.68P AD=1.68P PS=8.84U PD=8.84U
* device instance $70 r0 *1 1004.901,2 pfet
M$70 \$44 \$32 vdd vdd pfet L=0.5U W=4U AS=1.68P AD=1.68P PS=8.84U PD=8.84U
* device instance $71 r0 *1 1010.541,2 pfet
M$71 \$36 clk \$44 vdd pfet L=0.5U W=4U AS=1.68P AD=1.68P PS=8.84U PD=8.84U
* device instance $72 r0 *1 1016.181,2 pfet
M$72 \$45 \$35 vdd vdd pfet L=0.5U W=4U AS=1.68P AD=1.68P PS=8.84U PD=8.84U
* device instance $73 r0 *1 1021.821,2 pfet
M$73 clk \$36 \$45 vdd pfet L=0.5U W=4U AS=1.68P AD=1.68P PS=8.84U PD=8.84U
* device instance $74 r0 *1 933.331,2.82 pfet
M$74 \$6 \$9 vdd vdd pfet L=1U W=4U AS=1.68P AD=0.84P PS=8.84U PD=4.42U
* device instance $75 r0 *1 934.751,2.82 pfet
M$75 vdd \$9 \$6 vdd pfet L=1U W=4U AS=0.84P AD=0.84P PS=4.42U PD=4.42U
* device instance $76 r0 *1 936.171,2.82 pfet
M$76 \$6 \$9 vdd vdd pfet L=1U W=4U AS=0.84P AD=0.84P PS=4.42U PD=4.42U
* device instance $77 r0 *1 937.591,2.82 pfet
M$77 vdd \$9 \$6 vdd pfet L=1U W=4U AS=0.84P AD=1.68P PS=4.42U PD=8.84U
* device instance $78 r0 *1 943.481,1.82 pfet
M$78 \$42 \$8 \$6 vdd pfet L=0.5U W=2U AS=0.84P AD=0.42P PS=4.84U PD=2.42U
* device instance $79 r0 *1 944.401,1.82 pfet
M$79 \$6 \$8 \$42 vdd pfet L=0.5U W=2U AS=0.42P AD=0.42P PS=2.42U PD=2.42U
* device instance $80 r0 *1 945.321,1.82 pfet
M$80 \$42 \$8 \$6 vdd pfet L=0.5U W=2U AS=0.42P AD=0.42P PS=2.42U PD=2.42U
* device instance $81 r0 *1 946.241,1.82 pfet
M$81 \$6 \$8 \$42 vdd pfet L=0.5U W=2U AS=0.42P AD=0.84P PS=2.42U PD=4.84U
* device instance $82 r0 *1 951.881,1.82 pfet
M$82 \$33 \$26 \$6 vdd pfet L=0.5U W=2U AS=0.84P AD=0.42P PS=4.84U PD=2.42U
* device instance $83 r0 *1 952.801,1.82 pfet
M$83 \$6 \$26 \$33 vdd pfet L=0.5U W=2U AS=0.42P AD=0.42P PS=2.42U PD=2.42U
* device instance $84 r0 *1 953.721,1.82 pfet
M$84 \$33 \$26 \$6 vdd pfet L=0.5U W=2U AS=0.42P AD=0.42P PS=2.42U PD=2.42U
* device instance $85 r0 *1 954.641,1.82 pfet
M$85 \$6 \$26 \$33 vdd pfet L=0.5U W=2U AS=0.42P AD=0.84P PS=2.42U PD=4.84U
* device instance $86 r0 *1 1043.781,6 cap_mim_1f0_m4m5_noshield
C$86 vss \$26 2.172e-13 cap_mim_1f0_m4m5_noshield
* device instance $87 r0 *1 52.03,1 ppolyf_u_1k
R$87 vdd \$7 vsubs 50000 ppolyf_u_1k
* device instance $88 r0 *1 156.87,1 ppolyf_u_1k
R$88 \$7 \$8 vsubs 50000 ppolyf_u_1k
* device instance $89 r0 *1 261.71,1 ppolyf_u_1k
R$89 \$8 vss vsubs 50000 ppolyf_u_1k
* device instance $90 r0 *1 354.17,1 ppolyf_u_1k
R$90 \$1 vss vsubs 16000 ppolyf_u_1k
* device instance $91 r0 *1 428.979,1 ppolyf_u_1k
R$91 vdd \$10 vsubs 8599 ppolyf_u_1k
* device instance $92 r0 *1 442.792,1 ppolyf_u_1k
R$92 \$10 \$11 vsubs 374 ppolyf_u_1k
* device instance $93 r0 *1 459.214,1 ppolyf_u_1k
R$93 \$11 \$14 vsubs 748.5 ppolyf_u_1k
* device instance $94 r0 *1 476.759,1 ppolyf_u_1k
R$94 \$14 \$16 vsubs 1496.5 ppolyf_u_1k
* device instance $95 r0 *1 496.549,1 ppolyf_u_1k
R$95 \$16 \$18 vsubs 2993 ppolyf_u_1k
* device instance $96 r0 *1 520.828,1 ppolyf_u_1k
R$96 \$18 \$20 vsubs 5986 ppolyf_u_1k
* device instance $97 r0 *1 554.086,1 ppolyf_u_1k
R$97 \$20 \$22 vsubs 11972 ppolyf_u_1k
* device instance $98 r0 *1 605.302,1 ppolyf_u_1k
R$98 \$22 \$24 vsubs 23944 ppolyf_u_1k
* device instance $99 r0 *1 692.433,1 ppolyf_u_1k
R$99 \$24 \$26 vsubs 47887.5 ppolyf_u_1k
.ENDS rcosc_top
