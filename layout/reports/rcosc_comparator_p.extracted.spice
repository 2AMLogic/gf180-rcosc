* extracted by klt extract --deck gf180mcu

* cell rcosc_comparator_p
* pin inn
* pin inp
* pin out
* pin pb
* pin vdd
* pin vss
.SUBCKT rcosc_comparator_p inn inp out pb vdd vss
* device instance $1 r0 *1 12.35,0.25 nfet
M$1 \$2 \$9 vss vsubs nfet L=0.5U W=0.5U AS=0.21P AD=0.21P PS=1.84U PD=1.84U
* device instance $2 r0 *1 17.69,1 nfet
M$2 out \$2 vss vsubs nfet L=0.5U W=2U AS=0.84P AD=0.84P PS=4.84U PD=4.84U
* device instance $3 r0 *1 0.92,2 nfet
M$3 \$8 \$8 vss vsubs nfet L=1U W=4U AS=1.68P AD=1.68P PS=8.84U PD=8.84U
* device instance $4 r0 *1 6.76,2 nfet
M$4 \$9 \$8 vss vsubs nfet L=1U W=4U AS=1.68P AD=1.68P PS=8.84U PD=8.84U
* device instance $5 r0 *1 33.58,1.82 pfet
M$5 \$8 inp \$10 vdd pfet L=0.5U W=2U AS=0.84P AD=0.42P PS=4.84U PD=2.42U
* device instance $6 r0 *1 34.5,1.82 pfet
M$6 \$10 inp \$8 vdd pfet L=0.5U W=2U AS=0.42P AD=0.42P PS=2.42U PD=2.42U
* device instance $7 r0 *1 35.42,1.82 pfet
M$7 \$8 inp \$10 vdd pfet L=0.5U W=2U AS=0.42P AD=0.42P PS=2.42U PD=2.42U
* device instance $8 r0 *1 36.34,1.82 pfet
M$8 \$10 inp \$8 vdd pfet L=0.5U W=2U AS=0.42P AD=0.84P PS=2.42U PD=4.84U
* device instance $9 r0 *1 41.98,1.82 pfet
M$9 \$9 inn \$10 vdd pfet L=0.5U W=2U AS=0.84P AD=0.42P PS=4.84U PD=2.42U
* device instance $10 r0 *1 42.9,1.82 pfet
M$10 \$10 inn \$9 vdd pfet L=0.5U W=2U AS=0.42P AD=0.42P PS=2.42U PD=2.42U
* device instance $11 r0 *1 43.82,1.82 pfet
M$11 \$9 inn \$10 vdd pfet L=0.5U W=2U AS=0.42P AD=0.42P PS=2.42U PD=2.42U
* device instance $12 r0 *1 44.74,1.82 pfet
M$12 \$10 inn \$9 vdd pfet L=0.5U W=2U AS=0.42P AD=0.84P PS=2.42U PD=4.84U
* device instance $13 r0 *1 50.38,2 pfet
M$13 \$2 \$9 vdd vdd pfet L=0.5U W=4U AS=1.68P AD=1.68P PS=8.84U PD=8.84U
* device instance $14 r0 *1 56.02,2 pfet
M$14 out \$2 vdd vdd pfet L=0.5U W=4U AS=1.68P AD=1.68P PS=8.84U PD=8.84U
* device instance $15 r0 *1 23.43,2.82 pfet
M$15 \$10 pb vdd vdd pfet L=1U W=4U AS=1.68P AD=0.84P PS=8.84U PD=4.42U
* device instance $16 r0 *1 24.85,2.82 pfet
M$16 vdd pb \$10 vdd pfet L=1U W=4U AS=0.84P AD=0.84P PS=4.42U PD=4.42U
* device instance $17 r0 *1 26.27,2.82 pfet
M$17 \$10 pb vdd vdd pfet L=1U W=4U AS=0.84P AD=0.84P PS=4.42U PD=4.42U
* device instance $18 r0 *1 27.69,2.82 pfet
M$18 vdd pb \$10 vdd pfet L=1U W=4U AS=0.84P AD=1.68P PS=4.42U PD=8.84U
.ENDS rcosc_comparator_p
