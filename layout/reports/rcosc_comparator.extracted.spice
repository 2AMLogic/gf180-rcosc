* extracted by klt extract --deck gf180mcu

* cell rcosc_comparator
* pin ibias
* pin inn
* pin inp
* pin out
* pin vdd
* pin vss
.SUBCKT rcosc_comparator ibias inn inp out vdd vss
* device instance $1 r0 *1 27.13,1 nfet
M$1 out \$6 vss vsubs nfet L=0.5U W=2U AS=0.84P AD=0.84P PS=4.84U PD=4.84U
* device instance $2 r0 *1 0.92,1.82 nfet
M$2 \$5 ibias vss vsubs nfet L=1U W=2U AS=0.84P AD=0.42P PS=4.84U PD=2.42U
* device instance $3 r0 *1 2.34,1.82 nfet
M$3 vss ibias \$5 vsubs nfet L=1U W=2U AS=0.42P AD=0.42P PS=2.42U PD=2.42U
* device instance $4 r0 *1 3.76,1.82 nfet
M$4 \$5 ibias vss vsubs nfet L=1U W=2U AS=0.42P AD=0.42P PS=2.42U PD=2.42U
* device instance $5 r0 *1 5.18,1.82 nfet
M$5 vss ibias \$5 vsubs nfet L=1U W=2U AS=0.42P AD=0.42P PS=2.42U PD=2.42U
* device instance $6 r0 *1 6.6,1.82 nfet
M$6 \$5 ibias vss vsubs nfet L=1U W=2U AS=0.42P AD=0.42P PS=2.42U PD=2.42U
* device instance $7 r0 *1 8.02,1.82 nfet
M$7 vss ibias \$5 vsubs nfet L=1U W=2U AS=0.42P AD=0.42P PS=2.42U PD=2.42U
* device instance $8 r0 *1 9.44,1.82 nfet
M$8 \$5 ibias vss vsubs nfet L=1U W=2U AS=0.42P AD=0.42P PS=2.42U PD=2.42U
* device instance $9 r0 *1 10.86,1.82 nfet
M$9 vss ibias \$5 vsubs nfet L=1U W=2U AS=0.42P AD=0.84P PS=2.42U PD=4.84U
* device instance $10 r0 *1 16.45,2 nfet
M$10 \$6 inp \$5 vsubs nfet L=0.5U W=4U AS=1.68P AD=1.68P PS=8.84U PD=8.84U
* device instance $11 r0 *1 21.79,2 nfet
M$11 \$7 inn \$5 vsubs nfet L=0.5U W=4U AS=1.68P AD=1.68P PS=8.84U PD=8.84U
* device instance $12 r0 *1 32.87,2 pfet
M$12 \$7 \$7 vdd vdd pfet L=1U W=4U AS=1.68P AD=1.68P PS=8.84U PD=8.84U
* device instance $13 r0 *1 39.01,2 pfet
M$13 \$6 \$7 vdd vdd pfet L=1U W=4U AS=1.68P AD=1.68P PS=8.84U PD=8.84U
* device instance $14 r0 *1 44.9,2 pfet
M$14 out \$6 vdd vdd pfet L=0.5U W=4U AS=1.68P AD=1.68P PS=8.84U PD=8.84U
.ENDS rcosc_comparator
