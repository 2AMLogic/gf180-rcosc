* LVS reference for layout/cells/rcosc_top.gds -- generated by
* layout/build_cells.py from design/netlist/rcosc_top.spice.
* Sub-block .SUBCKTs below are byte-identical to the three per-cell
* references in layout/lvs_ref/ (same generator functions), so the
* hierarchy is verified against exactly what each cell was verified
* against on its own. See those files' headers, and layout/README.md,
* for the 'vsubs' bulk-tie accommodation and the plain-element
* resistor/capacitor form.
* CTIMING is a plain C element whose value is the deck's own two-term
* area+perimeter law for the gf180mcu MiM density this design commits
* to (cap_mim_1f0_m4m5_noshield, c_cox=9.87e-16 F/um^2 /
* c_capsw=3.3e-16 F/um, klayout_tools/decks/gf180mcu.py)
* evaluated at the schematic's own c_width/c_length -- not a retyped
* capacitance. Selected at extraction time with
* `klt extract --deck-option mim_cap=cap_mim_1f0_m4m5_noshield`.

.SUBCKT rcosc_bias vdd vss vh vl ibias pb vsubs
R$RBA vdd vh vsubs 50000 ppolyf_u_1k
R$RBB vh vl vsubs 50000 ppolyf_u_1k
R$RBC vl vss vsubs 50000 ppolyf_u_1k
R$RZ n2s vss vsubs 16000 ppolyf_u_1k
XN1 ibias ibias vss vsubs nfet_03v3 L=1u W=2u nf=1
XN2 pb ibias n2s vsubs nfet_03v3 L=1u W=16u nf=1
XP1 pb pb vdd vdd pfet_03v3 L=1u W=4u nf=1
XP2 ibias pb vdd vdd pfet_03v3 L=1u W=4u nf=1
XSEED pb vl vss vsubs nfet_03v3 L=20u W=2u nf=1
.ENDS
.SUBCKT rcosc_trim_bank p m vss t0 t1 t2 t3 t4 t5 t6 t7 vdd vsubs
R$RFIX p c1 vsubs 8599 ppolyf_u_1k
R$R0 c1 c2 vsubs 374.1 ppolyf_u_1k
R$R1 c2 c3 vsubs 748.25 ppolyf_u_1k
R$R2 c3 c4 vsubs 1496.5 ppolyf_u_1k
R$R3 c4 c5 vsubs 2992.95 ppolyf_u_1k
R$R4 c5 c6 vsubs 5985.95 ppolyf_u_1k
R$R5 c6 c7 vsubs 11971.9 ppolyf_u_1k
R$R6 c7 c8 vsubs 23943.8 ppolyf_u_1k
R$R7 c8 m vsubs 47887.5 ppolyf_u_1k
XSW0 c1 t0 c2 vsubs nfet_03v3 L=0.28u W=24u nf=1
XSW1 c2 t1 c3 vsubs nfet_03v3 L=0.28u W=16u nf=1
XSW2 c3 t2 c4 vsubs nfet_03v3 L=0.28u W=12u nf=1
XSW3 c4 t3 c5 vsubs nfet_03v3 L=0.28u W=8u nf=1
XSW4 c5 t4 c6 vsubs nfet_03v3 L=0.28u W=6u nf=1
XSW5 c6 t5 c7 vsubs nfet_03v3 L=0.28u W=5u nf=1
XSW6 c7 t6 c8 vsubs nfet_03v3 L=0.28u W=4u nf=1
XSW7 c8 t7 m vsubs nfet_03v3 L=0.28u W=3u nf=1
XPW0 c2 tb0 c1 vdd pfet_03v3 L=0.28u W=24u nf=1
XPW1 c3 tb1 c2 vdd pfet_03v3 L=0.28u W=16u nf=1
XPW2 c4 tb2 c3 vdd pfet_03v3 L=0.28u W=12u nf=1
XPW3 c5 tb3 c4 vdd pfet_03v3 L=0.28u W=8u nf=1
XPW4 c6 tb4 c5 vdd pfet_03v3 L=0.28u W=6u nf=1
XPW5 c7 tb5 c6 vdd pfet_03v3 L=0.28u W=5u nf=1
XPW6 c8 tb6 c7 vdd pfet_03v3 L=0.28u W=4u nf=1
XPW7 m tb7 c8 vdd pfet_03v3 L=0.28u W=3u nf=1
XNINV0 tb0 t0 vss vsubs nfet_03v3 L=0.5u W=2u nf=1
XNINV1 tb1 t1 vss vsubs nfet_03v3 L=0.5u W=2u nf=1
XNINV2 tb2 t2 vss vsubs nfet_03v3 L=0.5u W=2u nf=1
XNINV3 tb3 t3 vss vsubs nfet_03v3 L=0.5u W=2u nf=1
XNINV4 tb4 t4 vss vsubs nfet_03v3 L=0.5u W=2u nf=1
XNINV5 tb5 t5 vss vsubs nfet_03v3 L=0.5u W=2u nf=1
XNINV6 tb6 t6 vss vsubs nfet_03v3 L=0.5u W=2u nf=1
XNINV7 tb7 t7 vss vsubs nfet_03v3 L=0.5u W=2u nf=1
XPINV0 tb0 t0 vdd vdd pfet_03v3 L=0.5u W=4u nf=1
XPINV1 tb1 t1 vdd vdd pfet_03v3 L=0.5u W=4u nf=1
XPINV2 tb2 t2 vdd vdd pfet_03v3 L=0.5u W=4u nf=1
XPINV3 tb3 t3 vdd vdd pfet_03v3 L=0.5u W=4u nf=1
XPINV4 tb4 t4 vdd vdd pfet_03v3 L=0.5u W=4u nf=1
XPINV5 tb5 t5 vdd vdd pfet_03v3 L=0.5u W=4u nf=1
XPINV6 tb6 t6 vdd vdd pfet_03v3 L=0.5u W=4u nf=1
XPINV7 tb7 t7 vdd vdd pfet_03v3 L=0.5u W=4u nf=1
.ENDS
.SUBCKT rcosc_comparator vdd vss ibias inp inn out vsubs
XMTAIL tail ibias vss vsubs nfet_03v3 L=1u W=16u nf=1
XMINP dp inp tail vsubs nfet_03v3 L=0.5u W=4u nf=1
XMINN dn inn tail vsubs nfet_03v3 L=0.5u W=4u nf=1
XMBUFN out dp vss vsubs nfet_03v3 L=0.5u W=2u nf=1
XMLOADA dn dn vdd vdd pfet_03v3 L=1u W=4u nf=1
XMLOADB dp dn vdd vdd pfet_03v3 L=1u W=4u nf=1
XMBUFP out dp vdd vdd pfet_03v3 L=0.5u W=4u nf=1
.ENDS
.SUBCKT rcosc_comparator_p vdd vss pb inp inn out vsubs
XMNLOADA dn dn vss vsubs nfet_03v3 L=1u W=4u nf=1
XMNLOADB dp dn vss vsubs nfet_03v3 L=1u W=4u nf=1
XMBUFN outb dp vss vsubs nfet_03v3 L=0.5u W=0.5u nf=1
XMBUF2N out outb vss vsubs nfet_03v3 L=0.5u W=2u nf=1
XMPTAIL tailp pb vdd vdd pfet_03v3 L=1u W=16u nf=1
XMPINN dn inp tailp vdd pfet_03v3 L=0.5u W=8u nf=1
XMPINP dp inn tailp vdd pfet_03v3 L=0.5u W=8u nf=1
XMBUFP outb dp vdd vdd pfet_03v3 L=0.5u W=4u nf=1
XMBUF2P out outb vdd vdd pfet_03v3 L=0.5u W=4u nf=1
.ENDS
.SUBCKT rcosc_top vdd vss clk t0 t1 t2 t3 t4 t5 t6 t7
XXBIAS vdd vss vh vl ibias pb vsubs rcosc_bias
XXTRIM vdd vc vss t0 t1 t2 t3 t4 t5 t6 t7 vdd vsubs rcosc_trim_bank
C$CTIMING vss vc 2.172e-13 cap_mim_1f0_m4m5_noshield
XXCMPH vdd vss ibias vc vh cmph_out vsubs rcosc_comparator
XXCMPL vdd vss pb vl vc cmpl_out vsubs rcosc_comparator_p
XMDISCH vc clk vss vsubs nfet_03v3 L=0.5u W=20u nf=1
XMG1A qbar cmph_out vss vsubs nfet_03v3 L=0.5u W=2u nf=1
XMG1B qbar clk vss vsubs nfet_03v3 L=0.5u W=2u nf=1
XMG2A clk cmpl_out vss vsubs nfet_03v3 L=0.5u W=2u nf=1
XMG2B clk qbar vss vsubs nfet_03v3 L=0.5u W=2u nf=1
XMG1C mid1 cmph_out vdd vdd pfet_03v3 L=0.5u W=4u nf=1
XMG1D qbar clk mid1 vdd pfet_03v3 L=0.5u W=4u nf=1
XMG2C mid2 cmpl_out vdd vdd pfet_03v3 L=0.5u W=4u nf=1
XMG2D clk qbar mid2 vdd pfet_03v3 L=0.5u W=4u nf=1
.ENDS
