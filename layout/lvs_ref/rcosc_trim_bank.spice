* LVS reference for layout/cells/rcosc_trim_bank.gds -- generated by
* layout/build_cells.py from design/netlist/rcosc_top.spice.
* See rcosc_bias's reference netlist header (layout/build_cells.py)
* for why resistor bulk terminals are 'vsubs' here (not the
* schematic's 'vss') and resistors are plain R-elements.
* 'vss' is dropped from this SUBCKT's pin list (present in the
* schematic's rcosc_trim_bank p m vss t0..t7) for the same reason:
* it is used *only* as every device's bulk tie there, which this
* reference models as 'vsubs' instead -- so 'vss' would otherwise be
* an unused, arity-mismatched pin against the layout side (which
* never draws a 'vss' net at all, matching the deck's vsubs-only
* substrate model).
.SUBCKT rcosc_trim_bank p m t0 t1 t2 t3 t4 t5 t6 t7
R$RFIX p c1 vsubs 8599 ppolyf_u_1k
R$R0 c1 c2 vsubs 374.1 ppolyf_u_1k
R$R1 c2 c3 vsubs 748.25 ppolyf_u_1k
R$R2 c3 c4 vsubs 1496.5 ppolyf_u_1k
R$R3 c4 c5 vsubs 2992.95 ppolyf_u_1k
R$R4 c5 c6 vsubs 5985.95 ppolyf_u_1k
R$R5 c6 c7 vsubs 11971.9 ppolyf_u_1k
R$R6 c7 c8 vsubs 23943.8 ppolyf_u_1k
R$R7 c8 m vsubs 47887.5 ppolyf_u_1k
XSW0 c1 t0 c2 vsubs nfet_03v3 L=0.5u W=4u nf=1
XSW1 c2 t1 c3 vsubs nfet_03v3 L=0.5u W=4u nf=1
XSW2 c3 t2 c4 vsubs nfet_03v3 L=0.5u W=4u nf=1
XSW3 c4 t3 c5 vsubs nfet_03v3 L=0.5u W=4u nf=1
XSW4 c5 t4 c6 vsubs nfet_03v3 L=0.5u W=4u nf=1
XSW5 c6 t5 c7 vsubs nfet_03v3 L=0.5u W=4u nf=1
XSW6 c7 t6 c8 vsubs nfet_03v3 L=0.5u W=4u nf=1
XSW7 c8 t7 m vsubs nfet_03v3 L=0.5u W=4u nf=1
.ENDS
