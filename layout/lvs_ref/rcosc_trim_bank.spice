* LVS reference for layout/cells/rcosc_trim_bank.gds -- generated by
* layout/build_cells.py from design/netlist/rcosc_top.spice.
* See rcosc_bias's reference netlist header (layout/build_cells.py)
* for why resistor bulk terminals are 'vsubs' here (not the
* schematic's 'vss') and resistors are plain R-elements.
* Post-#43 (issue #50's re-spin) 'vdd' is a new pin and 'vss' is a
* real routed net again, not a bulk-only tie: the per-bit complement
* inverter's nfet sources sit on 'vss', its pfet sources (and the
* eight transmission-gate pfet bodies, through the cell's one drawn
* n-well tap) sit on 'vdd', so both stay in the pin list. NMOS and
* resistor bulk terminals still extract to the deck's synthesized
* 'vsubs'; the pfet bulk terminals are written 'vdd' as the schematic
* ties them, matched by the layout's drawn, tapped well.
.SUBCKT rcosc_trim_bank p m vss t0 t1 t2 t3 t4 t5 t6 t7 vdd
R$RFIX p c1 vsubs 8599 ppolyf_u_1k
R$R0 c1 c2 vsubs 374.1 ppolyf_u_1k
R$R1 c2 c3 vsubs 748.25 ppolyf_u_1k
R$R2 c3 c4 vsubs 1496.5 ppolyf_u_1k
R$R3 c4 c5 vsubs 2992.95 ppolyf_u_1k
R$R4 c5 c6 vsubs 5985.95 ppolyf_u_1k
R$R5 c6 c7 vsubs 11971.9 ppolyf_u_1k
R$R6 c7 c8 vsubs 23943.8 ppolyf_u_1k
R$R7 c8 m vsubs 47887.5 ppolyf_u_1k
XSW0 c1 t0 c2 vsubs nfet_03v3 L=0.28u W=24u nf=1
XSW1 c2 t1 c3 vsubs nfet_03v3 L=0.28u W=16u nf=1
XSW2 c3 t2 c4 vsubs nfet_03v3 L=0.28u W=12u nf=1
XSW3 c4 t3 c5 vsubs nfet_03v3 L=0.28u W=8u nf=1
XSW4 c5 t4 c6 vsubs nfet_03v3 L=0.28u W=6u nf=1
XSW5 c6 t5 c7 vsubs nfet_03v3 L=0.28u W=5u nf=1
XSW6 c7 t6 c8 vsubs nfet_03v3 L=0.28u W=4u nf=1
XSW7 c8 t7 m vsubs nfet_03v3 L=0.28u W=3u nf=1
XPW0 c2 tb0 c1 vdd pfet_03v3 L=0.28u W=24u nf=1
XPW1 c3 tb1 c2 vdd pfet_03v3 L=0.28u W=16u nf=1
XPW2 c4 tb2 c3 vdd pfet_03v3 L=0.28u W=12u nf=1
XPW3 c5 tb3 c4 vdd pfet_03v3 L=0.28u W=8u nf=1
XPW4 c6 tb4 c5 vdd pfet_03v3 L=0.28u W=6u nf=1
XPW5 c7 tb5 c6 vdd pfet_03v3 L=0.28u W=5u nf=1
XPW6 c8 tb6 c7 vdd pfet_03v3 L=0.28u W=4u nf=1
XPW7 m tb7 c8 vdd pfet_03v3 L=0.28u W=3u nf=1
XNINV0 tb0 t0 vss vsubs nfet_03v3 L=0.5u W=2u nf=1
XNINV1 tb1 t1 vss vsubs nfet_03v3 L=0.5u W=2u nf=1
XNINV2 tb2 t2 vss vsubs nfet_03v3 L=0.5u W=2u nf=1
XNINV3 tb3 t3 vss vsubs nfet_03v3 L=0.5u W=2u nf=1
XNINV4 tb4 t4 vss vsubs nfet_03v3 L=0.5u W=2u nf=1
XNINV5 tb5 t5 vss vsubs nfet_03v3 L=0.5u W=2u nf=1
XNINV6 tb6 t6 vss vsubs nfet_03v3 L=0.5u W=2u nf=1
XNINV7 tb7 t7 vss vsubs nfet_03v3 L=0.5u W=2u nf=1
XPINV0 tb0 t0 vdd vdd pfet_03v3 L=0.5u W=4u nf=1
XPINV1 tb1 t1 vdd vdd pfet_03v3 L=0.5u W=4u nf=1
XPINV2 tb2 t2 vdd vdd pfet_03v3 L=0.5u W=4u nf=1
XPINV3 tb3 t3 vdd vdd pfet_03v3 L=0.5u W=4u nf=1
XPINV4 tb4 t4 vdd vdd pfet_03v3 L=0.5u W=4u nf=1
XPINV5 tb5 t5 vdd vdd pfet_03v3 L=0.5u W=4u nf=1
XPINV6 tb6 t6 vdd vdd pfet_03v3 L=0.5u W=4u nf=1
XPINV7 tb7 t7 vdd vdd pfet_03v3 L=0.5u W=4u nf=1
.ENDS
