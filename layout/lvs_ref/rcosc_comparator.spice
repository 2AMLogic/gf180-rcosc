* LVS reference for layout/cells/rcosc_comparator.gds -- generated by
* layout/build_cells.py from design/netlist/rcosc_top.spice.
* See rcosc_bias's reference netlist header (layout/build_cells.py)
* for why every *NMOS* bulk terminal reads 'vsubs' here rather than
* the schematic's 'vss'. The three PMOS bulk terminals are NOT
* rewritten: this cell draws a real n-well tap ('klt gen well_island')
* tying the shared PMOS well to vdd, so the layout genuinely reports
* those bodies on the vdd net and no accommodation is needed.
* MTAIL is written 'W=16u nf=1' rather than the schematic's
* 'W=16u nf=8' -- the same device (gf180mcu's W is the total channel
* width), respelled because klt's reference normalizer rejects nf>1;
* the layout's eight drawn fingers are folded back together by
* klt lvs's options.combine_devices (see layout/run_checks.sh).
.SUBCKT rcosc_comparator vdd vss ibias inp inn out
XMTAIL tail ibias vss vsubs nfet_03v3 L=1u W=16u nf=1
XMINP dp inp tail vsubs nfet_03v3 L=0.5u W=4u nf=1
XMINN dn inn tail vsubs nfet_03v3 L=0.5u W=4u nf=1
XMBUFN out dp vss vsubs nfet_03v3 L=0.5u W=2u nf=1
XMLOADA dn dn vdd vdd pfet_03v3 L=1u W=4u nf=1
XMLOADB dp dn vdd vdd pfet_03v3 L=1u W=4u nf=1
XMBUFP out dp vdd vdd pfet_03v3 L=0.5u W=4u nf=1
.ENDS
