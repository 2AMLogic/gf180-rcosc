* LVS reference for layout/cells/rcosc_bias.gds -- generated by
* layout/build_cells.py from design/netlist/rcosc_top.spice.
*
* Every resistor/nfet's bulk terminal is tied to 'vsubs', not 'vss',
* matching klt's gf180mcu curated extraction deck: gf180mcu has no
* distinct tap layer, so every NMOS body / resistor bulk terminal is
* unconditionally tied to the deck's synthesized substrate_net global
* ('vsubs') regardless of drawn geometry (klayout_tools/decks/
* gf180mcu.py; klayout_tools/lvs.py's _body_net_warnings docstring).
* The schematic (design/rcosc_bias.sch) ties these same bulk terminals
* to 'vss' for correct SPICE simulation -- this is a disclosed LVS-
* reference-only modeling accommodation for that documented deck
* limitation, not a schematic or spec change (mirrors gf180-temp-por's
* lvs_reference.py: 'the deck ties every drawn resistor's bulk to its
* substrate global' -- see layout/README.md for the full rationale).
* The pfet bulk terminals are NOT rewritten: this cell draws a real
* n-well tap ('klt gen well_island', see build_rcosc_bias) tying the
* shared PMOS well to vdd, so the layout genuinely reports those
* bodies on the vdd net and the schematic's own vdd bulk connection
* compares directly, no accommodation needed (same construction as
* rcosc_comparator's, see the comparator's reference header).
* N2 is written 'W=16u nf=1' rather than the schematic's
* 'W=16u nf=8' -- the same device (gf180mcu's W is the total channel
* width), respelled because klt's reference normalizer rejects nf>1;
* the layout's eight drawn fingers are folded back together by
* klt lvs's options.combine_devices (see layout/run_checks.sh).
* Resistors are written as plain R-elements (value = sheet_rho *
* r_length/r_width) rather than X subckt calls: klt's subckt-call
* reference-netlist normalizer only converts MOS (l/w-bearing) X
* cards, not resistor (r_length/r_width) ones (klayout_tools/
* netlist_normalize.py) -- filed as klayout-tools#1550's sibling
* finding, see layout/README.md.
.SUBCKT rcosc_bias vdd vss vh vl ibias pb
R$RBA vdd vh vsubs 50000 ppolyf_u_1k
R$RBB vh vl vsubs 50000 ppolyf_u_1k
R$RBC vl vss vsubs 50000 ppolyf_u_1k
R$RZ n2s vss vsubs 16000 ppolyf_u_1k
XN1 ibias ibias vss vsubs nfet_03v3 L=1u W=2u nf=1
XN2 pb ibias n2s vsubs nfet_03v3 L=1u W=16u nf=1
XP1 pb pb vdd vdd pfet_03v3 L=1u W=4u nf=1
XP2 ibias pb vdd vdd pfet_03v3 L=1u W=4u nf=1
XSEED pb vl vss vsubs nfet_03v3 L=20u W=2u nf=1
.ENDS
