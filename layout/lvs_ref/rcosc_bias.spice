* LVS reference for layout/cells/rcosc_bias.gds -- generated by
* layout/build_cells.py from design/netlist/rcosc_top.spice.
*
* Every resistor/nfet's bulk terminal is tied to 'vsubs', not 'vss',
* matching klt's gf180mcu curated extraction deck: gf180mcu has no
* distinct tap layer, so every NMOS body / resistor bulk terminal is
* unconditionally tied to the deck's synthesized substrate_net global
* ('vsubs') regardless of drawn geometry (klayout_tools/decks/
* gf180mcu.py; klayout_tools/lvs.py's _body_net_warnings docstring).
* The schematic (design/rcosc_bias.sch) ties these same bulk terminals
* to 'vss' for correct SPICE simulation -- this is a disclosed LVS-
* reference-only modeling accommodation for that documented deck
* limitation, not a schematic or spec change (mirrors gf180-temp-por's
* lvs_reference.py: 'the deck ties every drawn resistor's bulk to its
* substrate global' -- see layout/README.md for the full rationale).
* Resistors are written as plain R-elements (value = sheet_rho *
* r_length/r_width) rather than X subckt calls: klt's subckt-call
* reference-netlist normalizer only converts MOS (l/w-bearing) X
* cards, not resistor (r_length/r_width) ones (klayout_tools/
* netlist_normalize.py) -- filed as klayout-tools#1550's sibling
* finding, see layout/README.md.
.SUBCKT rcosc_bias vdd vss vh vl ibias
R$RBA vdd vh vsubs 50000 ppolyf_u_1k
R$RBB vh vl vsubs 50000 ppolyf_u_1k
R$RBC vl vss vsubs 50000 ppolyf_u_1k
R$RBIAS vdd ibias vsubs 105000 ppolyf_u_1k
XMBIASD ibias ibias vss vsubs nfet_03v3 L=1u W=2u nf=1
.ENDS
