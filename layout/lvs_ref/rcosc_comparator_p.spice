* LVS reference for layout/cells/rcosc_comparator_p.gds -- generated by
* layout/build_cells.py from design/netlist/rcosc_top.spice.
* Same accommodations as rcosc_comparator's reference (see its header
* and rcosc_bias's): every *NMOS* bulk terminal reads 'vsubs' here
* rather than the schematic's 'vss' (the deck's synthesized substrate
* global), while the five PMOS bulk terminals are NOT rewritten -- this
* cell draws a real n-well tap ('klt gen well_island') tying the shared
* PMOS well to vdd, so the layout genuinely reports those bodies on
* the vdd net. The three multi-finger pfets (MPTAIL W=16u nf=4, and
* the W=8u nf=4 pair MPINN/MPINP) are written nf=1 at the schematic's
* total W -- gf180mcu's W is the total channel width -- because klt's
* reference normalizer rejects nf>1; the drawn fingers are folded back
* together by klt lvs's options.combine_devices: ["pfet"] (see
* layout/run_checks.sh).
.SUBCKT rcosc_comparator_p vdd vss pb inp inn out
XMNLOADA dn dn vss vsubs nfet_03v3 L=1u W=4u nf=1
XMNLOADB dp dn vss vsubs nfet_03v3 L=1u W=4u nf=1
XMBUFN outb dp vss vsubs nfet_03v3 L=0.5u W=0.5u nf=1
XMBUF2N out outb vss vsubs nfet_03v3 L=0.5u W=2u nf=1
XMPTAIL tailp pb vdd vdd pfet_03v3 L=1u W=16u nf=1
XMPINN dn inp tailp vdd pfet_03v3 L=0.5u W=8u nf=1
XMPINP dp inn tailp vdd pfet_03v3 L=0.5u W=8u nf=1
XMBUFP outb dp vdd vdd pfet_03v3 L=0.5u W=4u nf=1
XMBUF2P out outb vdd vdd pfet_03v3 L=0.5u W=4u nf=1
.ENDS
