* rcosc_top live trim-transition bench (v33_msb_first): VDD ramp 0->3.3 V in 1000 ns, then 32 timed +/-1 code events (generated by prepare.py)
* skew mode msb_first: per-bit step 1 ns, edge 1 ns
.param sw_stat_global=0 sw_stat_mismatch=0 mc_skew=3 res_mc_skew=3 cap_mc_skew=3 fnoicor=0
.options reltol=0.001 abstol=1e-12 vntol=1e-06
.include "rcosc_top_schematic.spice"
XXDUT vdd 0 clk t0 t1 t2 t3 t4 t5 t6 t7 rcosc_top
VDD vdd 0 PWL(0 0 1000n 3.3)
VT0 t0 0 PWL(0.0000n 0 1000.0000n 0 4507.0000n 0 4508.0000n 3.3 5207.0000n 3.3 5208.0000n 0
+ 5912.2500n 0 5913.2500n 3.3 6612.2500n 3.3 6613.2500n 0 7317.5000n 0 7318.5000n 3.3
+ 8017.5000n 3.3 8018.5000n 0 8722.7500n 0 8723.7500n 3.3 9422.7500n 3.3 9423.7500n 0
+ 10107.0000n 0 10108.0000n 3.3 11607.0000n 3.3 11608.0000n 0 12307.0000n 0 12308.0000n 3.3
+ 13012.2500n 3.3 13013.2500n 0 13712.2500n 0 13713.2500n 3.3 14417.5000n 3.3 14418.5000n 0
+ 15117.5000n 0 15118.5000n 3.3 15822.7500n 3.3 15823.7500n 0 16522.7500n 0 16523.7500n 3.3
+ 18707.0000n 3.3 18708.0000n 0 19407.0000n 0 19408.0000n 3.3 20112.2500n 3.3 20113.2500n 0
+ 20812.2500n 0 20813.2500n 3.3 21517.5000n 3.3 21518.5000n 0 22217.5000n 0 22218.5000n 3.3
+ 22922.7500n 3.3 22923.7500n 0 23622.7500n 0 23623.7500n 3.3 25807.0000n 3.3 25808.0000n 0
+ 26507.0000n 0 26508.0000n 3.3 27212.2500n 3.3 27213.2500n 0 27912.2500n 0 27913.2500n 3.3
+ 28617.5000n 3.3 28618.5000n 0 29317.5000n 0 29318.5000n 3.3 30022.7500n 3.3 30023.7500n 0
+ 30722.7500n 0 30723.7500n 3.3)
VT1 t1 0 PWL(0.0000n 0 1000.0000n 3.3 11606.0000n 3.3 11607.0000n 0 12306.0000n 0 12307.0000n 3.3
+ 13011.2500n 3.3 13012.2500n 0 13711.2500n 0 13712.2500n 3.3 14416.5000n 3.3 14417.5000n 0
+ 15116.5000n 0 15117.5000n 3.3 15821.7500n 3.3 15822.7500n 0 16521.7500n 0 16522.7500n 3.3
+ 18706.0000n 3.3 18707.0000n 0 19406.0000n 0 19407.0000n 3.3 20111.2500n 3.3 20112.2500n 0
+ 20811.2500n 0 20812.2500n 3.3 21516.5000n 3.3 21517.5000n 0 22216.5000n 0 22217.5000n 3.3
+ 22921.7500n 3.3 22922.7500n 0 23621.7500n 0 23622.7500n 3.3 25806.0000n 3.3 25807.0000n 0
+ 26506.0000n 0 26507.0000n 3.3 27211.2500n 3.3 27212.2500n 0 27911.2500n 0 27912.2500n 3.3
+ 28616.5000n 3.3 28617.5000n 0 29316.5000n 0 29317.5000n 3.3 30021.7500n 3.3 30022.7500n 0
+ 30721.7500n 0 30722.7500n 3.3)
VT2 t2 0 PWL(0.0000n 0 1000.0000n 0 10105.0000n 0 10106.0000n 3.3 11605.0000n 3.3 11606.0000n 0
+ 12305.0000n 0 12306.0000n 3.3 13010.2500n 3.3 13011.2500n 0 13710.2500n 0 13711.2500n 3.3
+ 14415.5000n 3.3 14416.5000n 0 15115.5000n 0 15116.5000n 3.3 15820.7500n 3.3 15821.7500n 0
+ 16520.7500n 0 16521.7500n 3.3 18705.0000n 3.3 18706.0000n 0 19405.0000n 0 19406.0000n 3.3
+ 20110.2500n 3.3 20111.2500n 0 20810.2500n 0 20811.2500n 3.3 21515.5000n 3.3 21516.5000n 0
+ 22215.5000n 0 22216.5000n 3.3 22920.7500n 3.3 22921.7500n 0 23620.7500n 0 23621.7500n 3.3
+ 25805.0000n 3.3 25806.0000n 0 26505.0000n 0 26506.0000n 3.3 27210.2500n 3.3 27211.2500n 0
+ 27910.2500n 0 27911.2500n 3.3 28615.5000n 3.3 28616.5000n 0 29315.5000n 0 29316.5000n 3.3
+ 30020.7500n 3.3 30021.7500n 0 30720.7500n 0 30721.7500n 3.3)
VT3 t3 0 PWL(0.0000n 0 1000.0000n 0 10104.0000n 0 10105.0000n 3.3 11604.0000n 3.3 11605.0000n 0
+ 12304.0000n 0 12305.0000n 3.3 13009.2500n 3.3 13010.2500n 0 13709.2500n 0 13710.2500n 3.3
+ 14414.5000n 3.3 14415.5000n 0 15114.5000n 0 15115.5000n 3.3 15819.7500n 3.3 15820.7500n 0
+ 16519.7500n 0 16520.7500n 3.3 18704.0000n 3.3 18705.0000n 0 19404.0000n 0 19405.0000n 3.3
+ 20109.2500n 3.3 20110.2500n 0 20809.2500n 0 20810.2500n 3.3 21514.5000n 3.3 21515.5000n 0
+ 22214.5000n 0 22215.5000n 3.3 22919.7500n 3.3 22920.7500n 0 23619.7500n 0 23620.7500n 3.3
+ 25804.0000n 3.3 25805.0000n 0 26504.0000n 0 26505.0000n 3.3 27209.2500n 3.3 27210.2500n 0
+ 27909.2500n 0 27910.2500n 3.3 28614.5000n 3.3 28615.5000n 0 29314.5000n 0 29315.5000n 3.3
+ 30019.7500n 3.3 30020.7500n 0 30719.7500n 0 30720.7500n 3.3)
VT4 t4 0 PWL(0.0000n 0 1000.0000n 0 10103.0000n 0 10104.0000n 3.3 11603.0000n 3.3 11604.0000n 0
+ 12303.0000n 0 12304.0000n 3.3 13008.2500n 3.3 13009.2500n 0 13708.2500n 0 13709.2500n 3.3
+ 14413.5000n 3.3 14414.5000n 0 15113.5000n 0 15114.5000n 3.3 15818.7500n 3.3 15819.7500n 0
+ 16518.7500n 0 16519.7500n 3.3 18703.0000n 3.3 18704.0000n 0 19403.0000n 0 19404.0000n 3.3
+ 20108.2500n 3.3 20109.2500n 0 20808.2500n 0 20809.2500n 3.3 21513.5000n 3.3 21514.5000n 0
+ 22213.5000n 0 22214.5000n 3.3 22918.7500n 3.3 22919.7500n 0 23618.7500n 0 23619.7500n 3.3
+ 25803.0000n 3.3 25804.0000n 0 26503.0000n 0 26504.0000n 3.3 27208.2500n 3.3 27209.2500n 0
+ 27908.2500n 0 27909.2500n 3.3 28613.5000n 3.3 28614.5000n 0 29313.5000n 0 29314.5000n 3.3
+ 30018.7500n 3.3 30019.7500n 0 30718.7500n 0 30719.7500n 3.3)
VT5 t5 0 PWL(0.0000n 0 1000.0000n 3.3 11602.0000n 3.3 11603.0000n 0 12302.0000n 0 12303.0000n 3.3
+ 13007.2500n 3.3 13008.2500n 0 13707.2500n 0 13708.2500n 3.3 14412.5000n 3.3 14413.5000n 0
+ 15112.5000n 0 15113.5000n 3.3 15817.7500n 3.3 15818.7500n 0 16517.7500n 0 16518.7500n 3.3
+ 18702.0000n 3.3 18703.0000n 0 19402.0000n 0 19403.0000n 3.3 20107.2500n 3.3 20108.2500n 0
+ 20807.2500n 0 20808.2500n 3.3 21512.5000n 3.3 21513.5000n 0 22212.5000n 0 22213.5000n 3.3
+ 22917.7500n 3.3 22918.7500n 0 23617.7500n 0 23618.7500n 3.3 25802.0000n 3.3 25803.0000n 0
+ 26502.0000n 0 26503.0000n 3.3 27207.2500n 3.3 27208.2500n 0 27907.2500n 0 27908.2500n 3.3
+ 28612.5000n 3.3 28613.5000n 0 29312.5000n 0 29313.5000n 3.3 30017.7500n 3.3 30018.7500n 0
+ 30717.7500n 0 30718.7500n 3.3)
VT6 t6 0 PWL(0.0000n 0 1000.0000n 0 11601.0000n 0 11602.0000n 3.3 12301.0000n 3.3 12302.0000n 0
+ 13006.2500n 0 13007.2500n 3.3 13706.2500n 3.3 13707.2500n 0 14411.5000n 0 14412.5000n 3.3
+ 15111.5000n 3.3 15112.5000n 0 15816.7500n 0 15817.7500n 3.3 16516.7500n 3.3 16517.7500n 0
+ 17201.0000n 0 17202.0000n 3.3 18701.0000n 3.3 18702.0000n 0 19401.0000n 0 19402.0000n 3.3
+ 20106.2500n 3.3 20107.2500n 0 20806.2500n 0 20807.2500n 3.3 21511.5000n 3.3 21512.5000n 0
+ 22211.5000n 0 22212.5000n 3.3 22916.7500n 3.3 22917.7500n 0 23616.7500n 0 23617.7500n 3.3
+ 24301.0000n 3.3 24302.0000n 0 25801.0000n 0 25802.0000n 3.3 26501.0000n 3.3 26502.0000n 0
+ 27206.2500n 0 27207.2500n 3.3 27906.2500n 3.3 27907.2500n 0 28611.5000n 0 28612.5000n 3.3
+ 29311.5000n 3.3 29312.5000n 0 30016.7500n 0 30017.7500n 3.3 30716.7500n 3.3 30717.7500n 0)
VT7 t7 0 PWL(0.0000n 0 1000.0000n 3.3 10100.0000n 3.3 10101.0000n 0 18700.0000n 0 18701.0000n 3.3
+ 19400.0000n 3.3 19401.0000n 0 20105.2500n 0 20106.2500n 3.3 20805.2500n 3.3 20806.2500n 0
+ 21510.5000n 0 21511.5000n 3.3 22210.5000n 3.3 22211.5000n 0 22915.7500n 0 22916.7500n 3.3
+ 23615.7500n 3.3 23616.7500n 0 24300.0000n 0 24301.0000n 3.3)
.save v(clk) v(vdd)
