* klt sim -- generated corner deck, do not edit
.lib /opt/pdk/gf180mcuC/libs.tech/ngspice/sm141064.ngspice typical
.lib /opt/pdk/gf180mcuC/libs.tech/ngspice/sm141064.ngspice res_typical
.lib /opt/pdk/gf180mcuC/libs.tech/ngspice/sm141064.ngspice mimcap_typical
.lib /opt/pdk/gf180mcuC/libs.tech/ngspice/sm141064.ngspice cap_mim
.include /var/tmp/eda-job-klt-sim-b58d9c86501b/inputs/netlist.cir
.temp 27.0
.meas tran t_first_edge WHEN v(clk)=1.5000 RISE=1
.control
set filetype=ascii
tran 100p 31400n 0 100p
write /var/tmp/eda-job-klt-sim-b58d9c86501b/outputs/artifacts/tt_novdd_27C/waveform.raw
quit
.endc
.end
