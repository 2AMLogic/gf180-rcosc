* trnoise availability smoke test (issue #213). Generic RC; no gf180mcu device, no DUT.
V1 n1 0 DC 0 trnoise(1m 10n 0 0)
R1 n1 out 1k
C1 out 0 1p
.end
