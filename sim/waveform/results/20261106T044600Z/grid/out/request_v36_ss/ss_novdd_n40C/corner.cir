* klt sim -- generated corner deck, do not edit
.lib /opt/pdk/gf180mcuC/libs.tech/ngspice/sm141064.ngspice ss
.lib /opt/pdk/gf180mcuC/libs.tech/ngspice/sm141064.ngspice res_ss
.lib /opt/pdk/gf180mcuC/libs.tech/ngspice/sm141064.ngspice mimcap_ss
.lib /opt/pdk/gf180mcuC/libs.tech/ngspice/sm141064.ngspice cap_mim
.include /var/tmp/eda-job-klt-sim-8f2d479015d8/inputs/netlist.cir
.temp -40.0
.meas tran t_first_edge WHEN v(clk)=1.8000 RISE=1
.control
set filetype=ascii
tran 200p 20000n 0 200p
write /var/tmp/eda-job-klt-sim-8f2d479015d8/outputs/artifacts/ss_novdd_n40C/waveform.raw
quit
.endc
.end
