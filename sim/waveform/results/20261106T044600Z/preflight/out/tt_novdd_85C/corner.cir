* klt sim -- generated corner deck, do not edit
.lib /opt/pdk/gf180mcuC/libs.tech/ngspice/sm141064.ngspice typical
.lib /opt/pdk/gf180mcuC/libs.tech/ngspice/sm141064.ngspice res_typical
.lib /opt/pdk/gf180mcuC/libs.tech/ngspice/sm141064.ngspice mimcap_typical
.lib /opt/pdk/gf180mcuC/libs.tech/ngspice/sm141064.ngspice cap_mim
.include /var/tmp/eda-job-klt-sim-2a8309a6a73f/inputs/netlist.cir
.temp 85.0
.meas tran t_first_edge WHEN v(clk)=1.6500 RISE=1
.control
set filetype=ascii
tran 200p 20000n 0 200p
write /var/tmp/eda-job-klt-sim-2a8309a6a73f/outputs/artifacts/tt_novdd_85C/waveform.raw
quit
.endc
.end
