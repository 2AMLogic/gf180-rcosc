* klt sim -- generated corner deck, do not edit
.lib /opt/pdk/gf180mcuC/libs.tech/ngspice/sm141064.ngspice typical
.lib /opt/pdk/gf180mcuC/libs.tech/ngspice/sm141064.ngspice res_typical
.lib /opt/pdk/gf180mcuC/libs.tech/ngspice/sm141064.ngspice mimcap_typical
.lib /opt/pdk/gf180mcuC/libs.tech/ngspice/sm141064.ngspice cap_mim
.include /var/tmp/eda-job-klt-sim-c27e82d19b4a/inputs/netlist.cir
.temp -40.0
.meas tran f_ta WHEN v(clk)=1.6500 RISE=5
.meas tran f_tb WHEN v(clk)=1.6500 RISE=25
.meas tran fosc PARAM='20/(f_tb-f_ta)'
.meas tran q_a FIND v(qint) WHEN v(clk)=1.6500 RISE=5
.meas tran q_b FIND v(qint) WHEN v(clk)=1.6500 RISE=25
.meas tran iq_run PARAM='(q_b-q_a)*1n/(f_tb-f_ta)'
.meas tran q_bias_a FIND v(pq_bias) WHEN v(clk)=1.6500 RISE=5
.meas tran q_bias_b FIND v(pq_bias) WHEN v(clk)=1.6500 RISE=25
.meas tran iq_bias PARAM='(q_bias_b-q_bias_a)*1n/(f_tb-f_ta)'
.meas tran q_cmp_h_a FIND v(pq_cmp_h) WHEN v(clk)=1.6500 RISE=5
.meas tran q_cmp_h_b FIND v(pq_cmp_h) WHEN v(clk)=1.6500 RISE=25
.meas tran iq_cmp_h PARAM='(q_cmp_h_b-q_cmp_h_a)*1n/(f_tb-f_ta)'
.meas tran q_cmp_l_a FIND v(pq_cmp_l) WHEN v(clk)=1.6500 RISE=5
.meas tran q_cmp_l_b FIND v(pq_cmp_l) WHEN v(clk)=1.6500 RISE=25
.meas tran iq_cmp_l PARAM='(q_cmp_l_b-q_cmp_l_a)*1n/(f_tb-f_ta)'
.meas tran q_latch_a FIND v(pq_latch) WHEN v(clk)=1.6500 RISE=5
.meas tran q_latch_b FIND v(pq_latch) WHEN v(clk)=1.6500 RISE=25
.meas tran iq_latch PARAM='(q_latch_b-q_latch_a)*1n/(f_tb-f_ta)'
.meas tran q_trim_a FIND v(pq_trim) WHEN v(clk)=1.6500 RISE=5
.meas tran q_trim_b FIND v(pq_trim) WHEN v(clk)=1.6500 RISE=25
.meas tran iq_trim PARAM='(q_trim_b-q_trim_a)*1n/(f_tb-f_ta)'
.control
save all
tran 200p 4000n
quit
.endc
.end
