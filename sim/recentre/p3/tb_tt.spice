* rcosc_top P3 range/post-trim bench, tt: XLO 0x00, XHI 0xFF, XCAL 0xA9 (generated by gen_requests.py)
.param sw_stat_global=0 sw_stat_mismatch=0 mc_skew=3 res_mc_skew=3 cap_mc_skew=3 fnoicor=0
.include "rcosc_top_p3.spice"
VDD vdd 0 DC 3.3
VHI vhi 0 DC 3.3
BMID vmid 0 V=v(vdd)/2
XLO vdd 0 clk_lo 0 0 0 0 0 0 0 0 rcosc_top
XHI vdd 0 clk_hi vhi vhi vhi vhi vhi vhi vhi vhi rcosc_top
XCAL vdd 0 clk_cal vhi 0 0 vhi 0 vhi 0 vhi rcosc_top
.save v(clk_lo) v(clk_hi) v(clk_cal) v(vmid)
