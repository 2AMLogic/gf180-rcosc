* klt sim -- generated corner deck, do not edit
.options seed=1041538739
.param mc_sample_index=3
.param mc_process_seed=1896205814
.param mc_mismatch_seed=916262379
.lib /opt/pdk/gf180mcuC/libs.tech/ngspice/sm141064.ngspice typical
.lib /opt/pdk/gf180mcuC/libs.tech/ngspice/sm141064.ngspice res_typical
.lib /opt/pdk/gf180mcuC/libs.tech/ngspice/sm141064.ngspice mimcap_typical
.lib /opt/pdk/gf180mcuC/libs.tech/ngspice/sm141064.ngspice cap_mim
.include /var/tmp/eda-job-klt-sim-dde147144b35/inputs/netlist.cir
.temp 27
.control
save all
op
let code_sel = $v_code
print code_sel
let f_sel_hz = $v_fsel
print f_sel_hz
let f_hold_hz = $v_fhold
print f_hold_hz
let resid_pct = $v_res
print resid_pct
let hold_gap_hz = $v_gap
print hold_gap_hz
quit
.endc
.end
