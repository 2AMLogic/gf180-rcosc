* extracted by klt extract --deck gf180mcu
* parasitic model (--parasitics):
* - capacitance: net-to-ground for every net's own (non-coupled) area/perimeter, plus net-to-net for the vertical-overlap coupling `coupling` describes below -- a coupled net pair gets a direct capacitor between their two hub nodes, not just capacitors to the deck's ground/substrate net
* - coupling: vertical overlap (crossover) unconditionally -- where one net's conductor on an adjacent metal level sits directly over another *distinct* net's conductor, that overlap area is charged between the two nets instead of to ground (issue #760) -- plus lateral (same-layer, sidewall) coupling, but only for a net pair naming one of the caller's declared `--critical-net` nets (issue #976): facing-edge length within that layer's own minimum-spacing lookback is charged between the two nets, *additively* (not deducted from either net's substrate fringe term, unlike the vertical case -- a known simplification). Any same-layer pair with neither side named `--critical-net`, and fringe shielding in general, are still not modelled
* - resistance: single lumped series resistance per net, distributed as a star across that net's device terminals (issue #592) -- not a per-segment, distributed RC ladder, *unless* `--distributed-rc` names this net via `--critical-net` (issue #977, Epic #709 Phase 2b): then the net's terminals are ordered along their approximate physical spread and its total R/C is broken into a chain of per-segment resistors (segment length proportional to inter-terminal distance) with a ground capacitor at each terminal node (proportional to its adjacent segment length/2), instead of one star hub -- still an approximation (terminal position is a device-placement proxy, not true per-segment routing geometry), but a strictly finer-grained one than the single-hub star
* - frequency: quasi-static -- one frequency-independent R and C per net; no skin effect, no distributed transmission-line behavior

* cell rcosc_top
* pin clk
* pin t0
* pin t1
* pin t2
* pin t3
* pin t4
* pin t5
* pin t6
* pin t7
* pin vdd
* pin vss
.SUBCKT rcosc_top clk t0 t1 t2 t3 t4 t5 t6 t7 vdd vss
* device instance $1 r0 *1 317.05,1 nfet
X$1 \$18__t0 \$18__t1 vss__t0 vsubs nfet_03v3 L=1U W=2U AS=0.84P AD=0.84P
+ PS=4.84U PD=4.84U
* device instance $2 r0 *1 385.01,1 nfet
X$2 \$19__t0 \$12__t0 vss__t2 vsubs nfet_03v3 L=20U W=2U AS=0.84P AD=0.84P
+ PS=4.84U PD=4.84U
* device instance $3 r0 *1 687.971,2 nfet
X$3 \$29__t0 \$14__t1 \$28__t0 vsubs nfet_03v3 L=0.5U W=4U AS=1.68P AD=1.68P
+ PS=8.84U PD=8.84U
* device instance $4 r0 *1 693.311,2 nfet
X$4 \$30__t0 \$11__t1 \$28__t1 vsubs nfet_03v3 L=0.5U W=4U AS=1.68P AD=1.68P
+ PS=8.84U PD=8.84U
* device instance $5 r0 *1 698.651,1 nfet
X$5 \$15__t0 \$29__t1 vss__t3 vsubs nfet_03v3 L=0.5U W=2U AS=0.84P AD=0.84P
+ PS=4.84U PD=4.84U
* device instance $6 r0 *1 745.941,2 nfet
X$6 \$32__t2 \$12__t1 \$31__t1 vsubs nfet_03v3 L=0.5U W=4U AS=1.68P AD=1.68P
+ PS=8.84U PD=8.84U
* device instance $7 r0 *1 751.281,2 nfet
X$7 \$33__t0 \$14__t5 \$31__t0 vsubs nfet_03v3 L=0.5U W=4U AS=1.68P AD=1.68P
+ PS=8.84U PD=8.84U
* device instance $8 r0 *1 756.621,1 nfet
X$8 \$16__t2 \$32__t1 vss__t10 vsubs nfet_03v3 L=0.5U W=2U AS=0.84P AD=0.84P
+ PS=4.84U PD=4.84U
* device instance $9 r0 *1 786.521,10 nfet
X$9 \$14__t2 clk__t0 vss__t4 vsubs nfet_03v3 L=0.5U W=20U AS=8.4P AD=8.4P
+ PS=40.84U PD=40.84U
* device instance $10 r0 *1 791.861,1 nfet
X$10 \$17__t2 \$15__t3 vss__t11 vsubs nfet_03v3 L=0.5U W=2U AS=0.84P AD=0.84P
+ PS=4.84U PD=4.84U
* device instance $11 r0 *1 797.201,1 nfet
X$11 \$17__t3 clk__t5 vss__t12 vsubs nfet_03v3 L=0.5U W=2U AS=0.84P AD=0.84P
+ PS=4.84U PD=4.84U
* device instance $12 r0 *1 802.541,1 nfet
X$12 clk__t3 \$16__t3 vss__t13 vsubs nfet_03v3 L=0.5U W=2U AS=0.84P AD=0.84P
+ PS=4.84U PD=4.84U
* device instance $13 r0 *1 807.881,1 nfet
X$13 clk__t4 \$17__t4 vss__t14 vsubs nfet_03v3 L=0.5U W=2U AS=0.84P AD=0.84P
+ PS=4.84U PD=4.84U
* device instance $14 r0 *1 322.89,1.82 nfet
X$14 \$19__t8 \$18__t2 \$1__t1 vsubs nfet_03v3 L=1U W=2U AS=0.84P AD=0.42P
+ PS=4.84U PD=2.42U
* device instance $15 r0 *1 324.31,1.82 nfet
X$15 \$1__t6 \$18__t3 \$19__t9 vsubs nfet_03v3 L=1U W=2U AS=0.42P AD=0.42P
+ PS=2.42U PD=2.42U
* device instance $16 r0 *1 325.73,1.82 nfet
X$16 \$19__t4 \$18__t7 \$1__t5 vsubs nfet_03v3 L=1U W=2U AS=0.42P AD=0.42P
+ PS=2.42U PD=2.42U
* device instance $17 r0 *1 327.15,1.82 nfet
X$17 \$1__t3 \$18__t8 \$19__t10 vsubs nfet_03v3 L=1U W=2U AS=0.42P AD=0.42P
+ PS=2.42U PD=2.42U
* device instance $18 r0 *1 328.57,1.82 nfet
X$18 \$19__t5 \$18__t9 \$1__t7 vsubs nfet_03v3 L=1U W=2U AS=0.42P AD=0.42P
+ PS=2.42U PD=2.42U
* device instance $19 r0 *1 329.99,1.82 nfet
X$19 \$1__t4 \$18__t10 \$19__t11 vsubs nfet_03v3 L=1U W=2U AS=0.42P AD=0.42P
+ PS=2.42U PD=2.42U
* device instance $20 r0 *1 331.41,1.82 nfet
X$20 \$19__t6 \$18__t11 \$1__t8 vsubs nfet_03v3 L=1U W=2U AS=0.42P AD=0.42P
+ PS=2.42U PD=2.42U
* device instance $21 r0 *1 332.83,1.82 nfet
X$21 \$1__t2 \$18__t4 \$19__t7 vsubs nfet_03v3 L=1U W=2U AS=0.42P AD=0.84P
+ PS=2.42U PD=4.84U
* device instance $22 r0 *1 672.441,1.82 nfet
X$22 \$28__t9 \$18__t25 vss__t9 vsubs nfet_03v3 L=1U W=2U AS=0.84P AD=0.42P
+ PS=4.84U PD=2.42U
* device instance $23 r0 *1 673.861,1.82 nfet
X$23 vss__t16 \$18__t12 \$28__t6 vsubs nfet_03v3 L=1U W=2U AS=0.42P AD=0.42P
+ PS=2.42U PD=2.42U
* device instance $24 r0 *1 675.281,1.82 nfet
X$24 \$28__t3 \$18__t13 vss__t22 vsubs nfet_03v3 L=1U W=2U AS=0.42P AD=0.42P
+ PS=2.42U PD=2.42U
* device instance $25 r0 *1 676.701,1.82 nfet
X$25 vss__t20 \$18__t19 \$28__t7 vsubs nfet_03v3 L=1U W=2U AS=0.42P AD=0.42P
+ PS=2.42U PD=2.42U
* device instance $26 r0 *1 678.121,1.82 nfet
X$26 \$28__t5 \$18__t22 vss__t26 vsubs nfet_03v3 L=1U W=2U AS=0.42P AD=0.42P
+ PS=2.42U PD=2.42U
* device instance $27 r0 *1 679.541,1.82 nfet
X$27 vss__t21 \$18__t21 \$28__t8 vsubs nfet_03v3 L=1U W=2U AS=0.42P AD=0.42P
+ PS=2.42U PD=2.42U
* device instance $28 r0 *1 680.961,1.82 nfet
X$28 \$28__t4 \$18__t20 vss__t25 vsubs nfet_03v3 L=1U W=2U AS=0.42P AD=0.42P
+ PS=2.42U PD=2.42U
* device instance $29 r0 *1 682.381,1.82 nfet
X$29 vss__t7 \$18__t6 \$28__t2 vsubs nfet_03v3 L=1U W=2U AS=0.42P AD=0.84P
+ PS=2.42U PD=4.84U
* device instance $30 r0 *1 730.411,1.82 nfet
X$30 \$31__t9 \$18__t24 vss__t8 vsubs nfet_03v3 L=1U W=2U AS=0.84P AD=0.42P
+ PS=4.84U PD=2.42U
* device instance $31 r0 *1 731.831,1.82 nfet
X$31 vss__t19 \$18__t18 \$31__t8 vsubs nfet_03v3 L=1U W=2U AS=0.42P AD=0.42P
+ PS=2.42U PD=2.42U
* device instance $32 r0 *1 733.251,1.82 nfet
X$32 \$31__t4 \$18__t17 vss__t24 vsubs nfet_03v3 L=1U W=2U AS=0.42P AD=0.42P
+ PS=2.42U PD=2.42U
* device instance $33 r0 *1 734.671,1.82 nfet
X$33 vss__t18 \$18__t16 \$31__t7 vsubs nfet_03v3 L=1U W=2U AS=0.42P AD=0.42P
+ PS=2.42U PD=2.42U
* device instance $34 r0 *1 736.091,1.82 nfet
X$34 \$31__t3 \$18__t15 vss__t23 vsubs nfet_03v3 L=1U W=2U AS=0.42P AD=0.42P
+ PS=2.42U PD=2.42U
* device instance $35 r0 *1 737.511,1.82 nfet
X$35 vss__t17 \$18__t14 \$31__t6 vsubs nfet_03v3 L=1U W=2U AS=0.42P AD=0.42P
+ PS=2.42U PD=2.42U
* device instance $36 r0 *1 738.931,1.82 nfet
X$36 \$31__t5 \$18__t23 vss__t27 vsubs nfet_03v3 L=1U W=2U AS=0.42P AD=0.42P
+ PS=2.42U PD=2.42U
* device instance $37 r0 *1 740.351,1.82 nfet
X$37 vss__t6 \$18__t5 \$31__t2 vsubs nfet_03v3 L=1U W=2U AS=0.42P AD=0.84P
+ PS=2.42U PD=4.84U
* device instance $38 r0 *1 441.182,7 nfet
X$38 \$3__t2 t0__t0 \$2__t2 vsubs nfet_03v3 L=0.5U W=4U AS=1.68P AD=1.68P
+ PS=8.84U PD=8.84U
* device instance $39 r0 *1 447.144,7 nfet
X$39 \$4__t2 t1__t0 \$3__t3 vsubs nfet_03v3 L=0.5U W=4U AS=1.68P AD=1.68P
+ PS=8.84U PD=8.84U
* device instance $40 r0 *1 454.23,7 nfet
X$40 \$5__t2 t2__t0 \$4__t3 vsubs nfet_03v3 L=0.5U W=4U AS=1.68P AD=1.68P
+ PS=8.84U PD=8.84U
* device instance $41 r0 *1 463.559,7 nfet
X$41 \$6__t2 t3__t0 \$5__t3 vsubs nfet_03v3 L=0.5U W=4U AS=1.68P AD=1.68P
+ PS=8.84U PD=8.84U
* device instance $42 r0 *1 477.378,7 nfet
X$42 \$7__t2 t4__t0 \$6__t3 vsubs nfet_03v3 L=0.5U W=4U AS=1.68P AD=1.68P
+ PS=8.84U PD=8.84U
* device instance $43 r0 *1 500.176,7 nfet
X$43 \$8__t2 t5__t0 \$7__t3 vsubs nfet_03v3 L=0.5U W=4U AS=1.68P AD=1.68P
+ PS=8.84U PD=8.84U
* device instance $44 r0 *1 540.932,7 nfet
X$44 \$9__t2 t6__t0 \$8__t3 vsubs nfet_03v3 L=0.5U W=4U AS=1.68P AD=1.68P
+ PS=8.84U PD=8.84U
* device instance $45 r0 *1 617.604,7 nfet
X$45 \$14__t4 t7__t0 \$9__t3 vsubs nfet_03v3 L=0.5U W=4U AS=1.68P AD=1.68P
+ PS=8.84U PD=8.84U
* device instance $46 r0 *1 400.5,2 pfet
X$46 \$19__t1 \$19__t2 vdd__t1 vdd__t2 pfet_03v3 L=1U W=4U AS=1.68P AD=1.68P
+ PS=8.84U PD=8.84U
* device instance $47 r0 *1 406.64,2 pfet
X$47 \$18__t26 \$19__t3 vdd__t22 vdd__t17 pfet_03v3 L=1U W=4U AS=1.68P AD=1.68P
+ PS=8.84U PD=8.84U
* device instance $48 r0 *1 704.391,2 pfet
X$48 \$30__t3 \$30__t1 vdd__t21 vdd__t16 pfet_03v3 L=1U W=4U AS=1.68P AD=1.68P
+ PS=8.84U PD=8.84U
* device instance $49 r0 *1 710.531,2 pfet
X$49 \$29__t3 \$30__t2 vdd__t23 vdd__t18 pfet_03v3 L=1U W=4U AS=1.68P AD=1.68P
+ PS=8.84U PD=8.84U
* device instance $50 r0 *1 716.421,2 pfet
X$50 \$15__t1 \$29__t2 vdd__t4 vdd__t5 pfet_03v3 L=0.5U W=4U AS=1.68P AD=1.68P
+ PS=8.84U PD=8.84U
* device instance $51 r0 *1 762.361,2 pfet
X$51 \$33__t3 \$33__t2 vdd__t20 vdd__t15 pfet_03v3 L=1U W=4U AS=1.68P AD=1.68P
+ PS=8.84U PD=8.84U
* device instance $52 r0 *1 768.501,2 pfet
X$52 \$32__t3 \$33__t1 vdd__t19 vdd__t14 pfet_03v3 L=1U W=4U AS=1.68P AD=1.68P
+ PS=8.84U PD=8.84U
* device instance $53 r0 *1 774.391,2 pfet
X$53 \$16__t0 \$32__t0 vdd__t13 vdd__t10 pfet_03v3 L=0.5U W=4U AS=1.68P
+ AD=1.68P PS=8.84U PD=8.84U
* device instance $54 r0 *1 813.371,2 pfet
X$54 \$34__t1 \$15__t2 vdd__t12 vdd__t9 pfet_03v3 L=0.5U W=4U AS=1.68P AD=1.68P
+ PS=8.84U PD=8.84U
* device instance $55 r0 *1 819.011,2 pfet
X$55 \$17__t0 clk__t2 \$34__t0 vdd__t8 pfet_03v3 L=0.5U W=4U AS=1.68P AD=1.68P
+ PS=8.84U PD=8.84U
* device instance $56 r0 *1 824.651,2 pfet
X$56 \$35__t1 \$16__t1 vdd__t11 vdd__t7 pfet_03v3 L=0.5U W=4U AS=1.68P AD=1.68P
+ PS=8.84U PD=8.84U
* device instance $57 r0 *1 830.291,2 pfet
X$57 clk__t1 \$17__t1 \$35__t0 vdd__t6 pfet_03v3 L=0.5U W=4U AS=1.68P AD=1.68P
+ PS=8.84U PD=8.84U
* device instance $58 r0 *1 852.251,6 cap_mim_1f0_m4m5_noshield
C$58 vss__t5 \$14__t3 2.172e-13
* device instance $59 r0 *1 52.03,1 ppolyf_u_1k
X$59 vdd__t0 \$11__t0 vsubs ppolyf_u_1k r_length=100U r_width=2U
* device instance $60 r0 *1 156.87,1 ppolyf_u_1k
X$60 \$11__t2 \$12__t2 vsubs ppolyf_u_1k r_length=100U r_width=2U
* device instance $61 r0 *1 261.71,1 ppolyf_u_1k
X$61 \$12__t3 vss__t15 vsubs ppolyf_u_1k r_length=100U r_width=2U
* device instance $62 r0 *1 354.17,1 ppolyf_u_1k
X$62 \$1__t0 vss__t1 vsubs ppolyf_u_1k r_length=32U r_width=2U
* device instance $63 r0 *1 427.369,1 ppolyf_u_1k
X$63 vdd__t3 \$2__t0 vsubs ppolyf_u_1k r_length=17.198U r_width=2U
* device instance $64 r0 *1 441.182,1 ppolyf_u_1k
X$64 \$2__t1 \$3__t0 vsubs ppolyf_u_1k r_length=0.748U r_width=2U
* device instance $65 r0 *1 447.144,1 ppolyf_u_1k
X$65 \$3__t1 \$4__t0 vsubs ppolyf_u_1k r_length=1.497U r_width=2U
* device instance $66 r0 *1 454.229,1 ppolyf_u_1k
X$66 \$4__t1 \$5__t0 vsubs ppolyf_u_1k r_length=2.993U r_width=2U
* device instance $67 r0 *1 463.559,1 ppolyf_u_1k
X$67 \$5__t1 \$6__t0 vsubs ppolyf_u_1k r_length=5.986U r_width=2U
* device instance $68 r0 *1 477.378,1 ppolyf_u_1k
X$68 \$6__t1 \$7__t0 vsubs ppolyf_u_1k r_length=11.972U r_width=2U
* device instance $69 r0 *1 500.176,1 ppolyf_u_1k
X$69 \$7__t1 \$8__t0 vsubs ppolyf_u_1k r_length=23.944U r_width=2U
* device instance $70 r0 *1 540.932,1 ppolyf_u_1k
X$70 \$8__t1 \$9__t0 vsubs ppolyf_u_1k r_length=47.888U r_width=2U
* device instance $71 r0 *1 617.603,1 ppolyf_u_1k
X$71 \$9__t1 \$14__t0 vsubs ppolyf_u_1k r_length=95.775U r_width=2U
* device instance _1_t0 r0 *1 0,0
R_1_t0 \$1__t0 \$1 21.4421114888
* device instance _1_t1 r0 *1 0,0
R_1_t1 \$1__t1 \$1 7.23398774743
* device instance _1_t2 r0 *1 0,0
R_1_t2 \$1__t2 \$1 1.87743719341
* device instance _1_t3 r0 *1 0,0
R_1_t3 \$1__t3 \$1 3.33065879522
* device instance _1_t4 r0 *1 0,0
R_1_t4 \$1__t4 \$1 0.731795032845
* device instance _1_t5 r0 *1 0,0
R_1_t5 \$1__t5 \$1 4.63166265634
* device instance _1_t6 r0 *1 0,0
R_1_t6 \$1__t6 \$1 5.93279550764
* device instance _1_t7 r0 *1 0,0
R_1_t7 \$1__t7 \$1 2.03003194051
* device instance _1_t8 r0 *1 0,0
R_1_t8 \$1__t8 \$1 0.580319637779
* device instance _1 r0 *1 0,0
C_1 \$1 vsubs 5.580955e-15
* device instance _11_t0 r0 *1 0,0
R_11_t0 \$11__t0 \$11 81.8905068354
* device instance _11_t1 r0 *1 0,0
R_11_t1 \$11__t1 \$11 129.260942843
* device instance _11_t2 r0 *1 0,0
R_11_t2 \$11__t2 \$11 47.3704503215
* device instance _11 r0 *1 0,0
C_11 \$11 vsubs 4.4086358e-14
* device instance _12_t0 r0 *1 0,0
R_12_t0 \$12__t0 \$12 1.06042450076
* device instance _12_t1 r0 *1 0,0
R_12_t1 \$12__t1 \$12 159.364320169
* device instance _12_t2 r0 *1 0,0
R_12_t2 \$12__t2 \$12 102.453224644
* device instance _12_t3 r0 *1 0,0
R_12_t3 \$12__t3 \$12 55.8563306858
* device instance _12 r0 *1 0,0
C_12 \$12 vsubs 5.4393409e-14
* device instance _14_t0 r0 *1 0,0
R_14_t0 \$14__t0 \$14 40.3107765061
* device instance _14_t1 r0 *1 0,0
R_14_t1 \$14__t1 \$14 12.3379278137
* device instance _14_t2 r0 *1 0,0
R_14_t2 \$14__t2 \$14 26.9940975512
* device instance _14_t3 r0 *1 0,0
R_14_t3 \$14__t3 \$14 53.0604061095
* device instance _14_t4 r0 *1 0,0
R_14_t4 \$14__t4 \$14 40.2946735535
* device instance _14_t5 r0 *1 0,0
R_14_t5 \$14__t5 \$14 12.935818466
* device instance _14 r0 *1 0,0
C_14 \$14 vsubs 3.0004323e-14
* device instance _15_t0 r0 *1 0,0
R_15_t0 \$15__t0 \$15 29.1214186394
* device instance _15_t1 r0 *1 0,0
R_15_t1 \$15__t1 \$15 19.9510572829
* device instance _15_t2 r0 *1 0,0
R_15_t2 \$15__t2 \$15 30.0864668562
* device instance _15_t3 r0 *1 0,0
R_15_t3 \$15__t3 \$15 18.9860572214
* device instance _15 r0 *1 0,0
C_15 \$15 vsubs 1.631116e-14
* device instance _16_t0 r0 *1 0,0
R_16_t0 \$16__t0 \$16 13.9878143553
* device instance _16_t1 r0 *1 0,0
R_16_t1 \$16__t1 \$16 32.3717183932
* device instance _16_t2 r0 *1 0,0
R_16_t2 \$16__t2 \$16 30.3708093374
* device instance _16_t3 r0 *1 0,0
R_16_t3 \$16__t3 \$16 11.9879579141
* device instance _16 r0 *1 0,0
C_16 \$16 vsubs 1.3504915e-14
* device instance _17_t0 r0 *1 0,0
R_17_t0 \$17__t0 \$17 14.6109957075
* device instance _17_t1 r0 *1 0,0
R_17_t1 \$17__t1 \$17 31.4474723371
* device instance _17_t2 r0 *1 0,0
R_17_t2 \$17__t2 \$17 25.9828483646
* device instance _17_t3 r0 *1 0,0
R_17_t3 \$17__t3 \$17 18.0084538062
* device instance _17_t4 r0 *1 0,0
R_17_t4 \$17__t4 \$17 2.12922978461
* device instance _17 r0 *1 0,0
C_17 \$17 vsubs 1.4418789e-14
* device instance _18_t0 r0 *1 0,0
R_18_t0 \$18__t0 \$18 39.9157135616
* device instance _18_t1 r0 *1 0,0
R_18_t1 \$18__t1 \$18 39.9157135616
* device instance _18_t2 r0 *1 0,0
R_18_t2 \$18__t2 \$18 38.9329490024
* device instance _18_t3 r0 *1 0,0
R_18_t3 \$18__t3 \$18 38.6940394534
* device instance _18_t4 r0 *1 0,0
R_18_t4 \$18__t4 \$18 37.260582161
* device instance _18_t5 r0 *1 0,0
R_18_t5 \$18__t5 \$18 31.3032660479
* device instance _18_t6 r0 *1 0,0
R_18_t6 \$18__t6 \$18 21.5500364087
* device instance _18_t7 r0 *1 0,0
R_18_t7 \$18__t7 \$18 38.4551299044
* device instance _18_t8 r0 *1 0,0
R_18_t8 \$18__t8 \$18 38.2162203556
* device instance _18_t9 r0 *1 0,0
R_18_t9 \$18__t9 \$18 37.9773108068
* device instance _18_t10 r0 *1 0,0
R_18_t10 \$18__t10 \$18 37.7384012581
* device instance _18_t11 r0 *1 0,0
R_18_t11 \$18__t11 \$18 37.4994917095
* device instance _18_t12 r0 *1 0,0
R_18_t12 \$18__t12 \$18 20.116579212
* device instance _18_t13 r0 *1 0,0
R_18_t13 \$18__t13 \$18 20.3554887434
* device instance _18_t14 r0 *1 0,0
R_18_t14 \$18__t14 \$18 30.8254469572
* device instance _18_t15 r0 *1 0,0
R_18_t15 \$18__t15 \$18 30.5865374121
* device instance _18_t16 r0 *1 0,0
R_18_t16 \$18__t16 \$18 30.3476278672
* device instance _18_t17 r0 *1 0,0
R_18_t17 \$18__t17 \$18 30.1087183224
* device instance _18_t18 r0 *1 0,0
R_18_t18 \$18__t18 \$18 29.8698087778
* device instance _18_t19 r0 *1 0,0
R_18_t19 \$18__t19 \$18 20.5943982754
* device instance _18_t20 r0 *1 0,0
R_18_t20 \$18__t20 \$18 21.3111268746
* device instance _18_t21 r0 *1 0,0
R_18_t21 \$18__t21 \$18 21.0722173411
* device instance _18_t22 r0 *1 0,0
R_18_t22 \$18__t22 \$18 20.833307808
* device instance _18_t23 r0 *1 0,0
R_18_t23 \$18__t23 \$18 31.0643565025
* device instance _18_t24 r0 *1 0,0
R_18_t24 \$18__t24 \$18 29.6308992334
* device instance _18_t25 r0 *1 0,0
R_18_t25 \$18__t25 \$18 19.8776696811
* device instance _18_t26 r0 *1 0,0
R_18_t26 \$18__t26 \$18 24.8423627606
* device instance _18 r0 *1 0,0
C_18 \$18 vsubs 5.334274e-14
* device instance _19_t0 r0 *1 0,0
R_19_t0 \$19__t0 \$19 6.9216653283
* device instance _19_t1 r0 *1 0,0
R_19_t1 \$19__t1 \$19 10.0989400282
* device instance _19_t2 r0 *1 0,0
R_19_t2 \$19__t2 \$19 10.0989400282
* device instance _19_t3 r0 *1 0,0
R_19_t3 \$19__t3 \$19 11.3590851673
* device instance _19_t4 r0 *1 0,0
R_19_t4 \$19__t4 \$19 5.2467130798
* device instance _19_t5 r0 *1 0,0
R_19_t5 \$19__t5 \$19 4.66384049288
* device instance _19_t6 r0 *1 0,0
R_19_t6 \$19__t6 \$19 4.08096798399
* device instance _19_t7 r0 *1 0,0
R_19_t7 \$19__t7 \$19 3.78953177005
* device instance _19_t8 r0 *1 0,0
R_19_t8 \$19__t8 \$19 5.82958572134
* device instance _19_t9 r0 *1 0,0
R_19_t9 \$19__t9 \$19 5.53814939482
* device instance _19_t10 r0 *1 0,0
R_19_t10 \$19__t10 \$19 4.95527677831
* device instance _19_t11 r0 *1 0,0
R_19_t11 \$19__t11 \$19 4.37240422673
* device instance _19 r0 *1 0,0
C_19 \$19 vsubs 1.0532991e-14
* device instance _2_t0 r0 *1 0,0
R_2_t0 \$2__t0 \$2 40.2660349623
* device instance _2_t1 r0 *1 0,0
R_2_t1 \$2__t1 \$2 21.4502711882
* device instance _2_t2 r0 *1 0,0
R_2_t2 \$2__t2 \$2 26.0617938495
* device instance _2 r0 *1 0,0
C_2 \$2 vsubs 2.149755e-15
* device instance _28_t0 r0 *1 0,0
R_28_t0 \$28__t0 \$28 1.97061995882
* device instance _28_t1 r0 *1 0,0
R_28_t1 \$28__t1 \$28 3.29995142294
* device instance _28_t2 r0 *1 0,0
R_28_t2 \$28__t2 \$28 0.57865961447
* device instance _28_t3 r0 *1 0,0
R_28_t3 \$28__t3 \$28 1.18908145352
* device instance _28_t4 r0 *1 0,0
R_28_t4 \$28__t4 \$28 0.225241014832
* device instance _28_t5 r0 *1 0,0
R_28_t5 \$28__t5 \$28 0.482075848326
* device instance _28_t6 r0 *1 0,0
R_28_t6 \$28__t6 \$28 1.54260128741
* device instance _28_t7 r0 *1 0,0
R_28_t7 \$28__t7 \$28 0.835568170152
* device instance _28_t8 r0 *1 0,0
R_28_t8 \$28__t8 \$28 0.128777221598
* device instance _28_t9 r0 *1 0,0
R_28_t9 \$28__t9 \$28 1.89612400793
* device instance _28 r0 *1 0,0
C_28 \$28 vsubs 4.987296e-15
* device instance _29_t0 r0 *1 0,0
R_29_t0 \$29__t0 \$29 24.2773862501
* device instance _29_t1 r0 *1 0,0
R_29_t1 \$29__t1 \$29 7.557208718
* device instance _29_t2 r0 *1 0,0
R_29_t2 \$29__t2 \$29 20.5083694185
* device instance _29_t3 r0 *1 0,0
R_29_t3 \$29__t3 \$29 11.2409356134
* device instance _29 r0 *1 0,0
C_29 \$29 vsubs 5.708392e-15
* device instance _3_t0 r0 *1 0,0
R_3_t0 \$3__t0 \$3 22.258675
* device instance _3_t1 r0 *1 0,0
R_3_t1 \$3__t1 \$3 22.258675
* device instance _3_t2 r0 *1 0,0
R_3_t2 \$3__t2 \$3 22.258675
* device instance _3_t3 r0 *1 0,0
R_3_t3 \$3__t3 \$3 22.258675
* device instance _3 r0 *1 0,0
C_3 \$3 vsubs 2.832891e-15
* device instance _30_t0 r0 *1 0,0
R_30_t0 \$30__t0 \$30 29.99065
* device instance _30_t1 r0 *1 0,0
R_30_t1 \$30__t1 \$30 3.7621587354
* device instance _30_t2 r0 *1 0,0
R_30_t2 \$30__t2 \$30 22.4663325292
* device instance _30_t3 r0 *1 0,0
R_30_t3 \$30__t3 \$30 3.7621587354
* device instance _30 r0 *1 0,0
C_30 \$30 vsubs 4.39074e-15
* device instance _31_t0 r0 *1 0,0
R_31_t0 \$31__t0 \$31 3.29995142294
* device instance _31_t1 r0 *1 0,0
R_31_t1 \$31__t1 \$31 1.97061995882
* device instance _31_t2 r0 *1 0,0
R_31_t2 \$31__t2 \$31 0.57865961447
* device instance _31_t3 r0 *1 0,0
R_31_t3 \$31__t3 \$31 0.482075848326
* device instance _31_t4 r0 *1 0,0
R_31_t4 \$31__t4 \$31 1.18908145352
* device instance _31_t5 r0 *1 0,0
R_31_t5 \$31__t5 \$31 0.225241014832
* device instance _31_t6 r0 *1 0,0
R_31_t6 \$31__t6 \$31 0.128777221598
* device instance _31_t7 r0 *1 0,0
R_31_t7 \$31__t7 \$31 0.835568170152
* device instance _31_t8 r0 *1 0,0
R_31_t8 \$31__t8 \$31 1.54260128741
* device instance _31_t9 r0 *1 0,0
R_31_t9 \$31__t9 \$31 1.89612400793
* device instance _31 r0 *1 0,0
C_31 \$31 vsubs 4.987296e-15
* device instance _32_t0 r0 *1 0,0
R_32_t0 \$32__t0 \$32 20.5083694185
* device instance _32_t1 r0 *1 0,0
R_32_t1 \$32__t1 \$32 7.557208718
* device instance _32_t2 r0 *1 0,0
R_32_t2 \$32__t2 \$32 24.2773862501
* device instance _32_t3 r0 *1 0,0
R_32_t3 \$32__t3 \$32 11.2409356134
* device instance _32 r0 *1 0,0
C_32 \$32 vsubs 5.708392e-15
* device instance _33_t0 r0 *1 0,0
R_33_t0 \$33__t0 \$33 29.99065
* device instance _33_t1 r0 *1 0,0
R_33_t1 \$33__t1 \$33 22.4663325292
* device instance _33_t2 r0 *1 0,0
R_33_t2 \$33__t2 \$33 3.7621587354
* device instance _33_t3 r0 *1 0,0
R_33_t3 \$33__t3 \$33 3.7621587354
* device instance _33 r0 *1 0,0
C_33 \$33 vsubs 4.39074e-15
* device instance _34_t0 r0 *1 0,0
R_34_t0 \$34__t0 \$34 7.328
* device instance _34_t1 r0 *1 0,0
R_34_t1 \$34__t1 \$34 7.328
* device instance _34 r0 *1 0,0
C_34 \$34 vsubs 5.112189e-15
* device instance _35_t0 r0 *1 0,0
R_35_t0 \$35__t0 \$35 7.5208
* device instance _35_t1 r0 *1 0,0
R_35_t1 \$35__t1 \$35 7.5208
* device instance _35 r0 *1 0,0
C_35 \$35 vsubs 5.248712e-15
* device instance _4_t0 r0 *1 0,0
R_4_t0 \$4__t0 \$4 22.309974973
* device instance _4_t1 r0 *1 0,0
R_4_t1 \$4__t1 \$4 22.308141275
* device instance _4_t2 r0 *1 0,0
R_4_t2 \$4__t2 \$4 22.309974973
* device instance _4_t3 r0 *1 0,0
R_4_t3 \$4__t3 \$4 22.311808779
* device instance _4 r0 *1 0,0
C_4 \$4 vsubs 2.93461e-15
* device instance _5_t0 r0 *1 0,0
R_5_t0 \$5__t0 \$5 22.4127243338
* device instance _5_t1 r0 *1 0,0
R_5_t1 \$5__t1 \$5 22.4110249867
* device instance _5_t2 r0 *1 0,0
R_5_t2 \$5__t2 \$5 22.4093256929
* device instance _5_t3 r0 *1 0,0
R_5_t3 \$5__t3 \$5 22.4110249867
* device instance _5 r0 *1 0,0
C_5 \$5 vsubs 3.13976e-15
* device instance _6_t0 r0 *1 0,0
R_6_t0 \$6__t0 \$6 22.618975
* device instance _6_t1 r0 *1 0,0
R_6_t1 \$6__t1 \$6 22.618975
* device instance _6_t2 r0 *1 0,0
R_6_t2 \$6__t2 \$6 22.618975
* device instance _6_t3 r0 *1 0,0
R_6_t3 \$6__t3 \$6 22.618975
* device instance _6 r0 *1 0,0
C_6 \$6 vsubs 3.550424e-15
* device instance _7_t0 r0 *1 0,0
R_7_t0 \$7__t0 \$7 23.051
* device instance _7_t1 r0 *1 0,0
R_7_t1 \$7__t1 \$7 23.051
* device instance _7_t2 r0 *1 0,0
R_7_t2 \$7__t2 \$7 23.051
* device instance _7_t3 r0 *1 0,0
R_7_t3 \$7__t3 \$7 23.051
* device instance _7 r0 *1 0,0
C_7 \$7 vsubs 4.371661e-15
* device instance _8_t0 r0 *1 0,0
R_8_t0 \$8__t0 \$8 23.95165
* device instance _8_t1 r0 *1 0,0
R_8_t1 \$8__t1 \$8 23.95165
* device instance _8_t2 r0 *1 0,0
R_8_t2 \$8__t2 \$8 23.95165
* device instance _8_t3 r0 *1 0,0
R_8_t3 \$8__t3 \$8 23.95165
* device instance _8 r0 *1 0,0
C_8 \$8 vsubs 6.014136e-15
* device instance _9_t0 r0 *1 0,0
R_9_t0 \$9__t0 \$9 25.81415
* device instance _9_t1 r0 *1 0,0
R_9_t1 \$9__t1 \$9 25.8138153642
* device instance _9_t2 r0 *1 0,0
R_9_t2 \$9__t2 \$9 25.81415
* device instance _9_t3 r0 *1 0,0
R_9_t3 \$9__t3 \$9 25.8144846358
* device instance _9 r0 *1 0,0
C_9 \$9 vsubs 9.299085e-15
* device instance clk_t0 r0 *1 0,0
Rclk_t0 clk__t0 clk 39.4944734745
* device instance clk_t1 r0 *1 0,0
Rclk_t1 clk__t1 clk 41.5492407304
* device instance clk_t2 r0 *1 0,0
Rclk_t2 clk__t2 clk 21.2554739297
* device instance clk_t3 r0 *1 0,0
Rclk_t3 clk__t3 clk 9.08786561615
* device instance clk_t4 r0 *1 0,0
Rclk_t4 clk__t4 clk 3.49800280419
* device instance clk_t5 r0 *1 0,0
Rclk_t5 clk__t5 clk 18.3850434451
* device instance clk r0 *1 0,0
Cclk clk vsubs 1.715673e-14
* device instance t0_t0 r0 *1 0,0
Rt0_t0 t0__t0 t0 21.3388
* device instance t0 r0 *1 0,0
Ct0 t0 vsubs 2.650248e-15
* device instance t1_t0 r0 *1 0,0
Rt1_t0 t1__t0 t1 21.3388
* device instance t1 r0 *1 0,0
Ct1 t1 vsubs 2.650248e-15
* device instance t2_t0 r0 *1 0,0
Rt2_t0 t2__t0 t2 21.3388
* device instance t2 r0 *1 0,0
Ct2 t2 vsubs 2.650248e-15
* device instance t3_t0 r0 *1 0,0
Rt3_t0 t3__t0 t3 21.3388
* device instance t3 r0 *1 0,0
Ct3 t3 vsubs 2.650248e-15
* device instance t4_t0 r0 *1 0,0
Rt4_t0 t4__t0 t4 21.3388
* device instance t4 r0 *1 0,0
Ct4 t4 vsubs 2.650248e-15
* device instance t5_t0 r0 *1 0,0
Rt5_t0 t5__t0 t5 21.3388
* device instance t5 r0 *1 0,0
Ct5 t5 vsubs 2.650248e-15
* device instance t6_t0 r0 *1 0,0
Rt6_t0 t6__t0 t6 21.3388
* device instance t6 r0 *1 0,0
Ct6 t6 vsubs 2.650248e-15
* device instance t7_t0 r0 *1 0,0
Rt7_t0 t7__t0 t7 21.3388
* device instance t7 r0 *1 0,0
Ct7 t7 vsubs 2.650248e-15
* device instance vdd_t0 r0 *1 0,0
Rvdd_t0 vdd__t0 vdd 73.1755809188
* device instance vdd_t1 r0 *1 0,0
Rvdd_t1 vdd__t1 vdd 31.3830795974
* device instance vdd_t2 r0 *1 0,0
Rvdd_t2 vdd__t2 vdd 31.3830795974
* device instance vdd_t3 r0 *1 0,0
Rvdd_t3 vdd__t3 vdd 28.1608615653
* device instance vdd_t4 r0 *1 0,0
Rvdd_t4 vdd__t4 vdd 6.50570983258
* device instance vdd_t5 r0 *1 0,0
Rvdd_t5 vdd__t5 vdd 6.50570983258
* device instance vdd_t6 r0 *1 0,0
Rvdd_t6 vdd__t6 vdd 20.1622687645
* device instance vdd_t7 r0 *1 0,0
Rvdd_t7 vdd__t7 vdd 19.4858569623
* device instance vdd_t8 r0 *1 0,0
Rvdd_t8 vdd__t8 vdd 18.8094451664
* device instance vdd_t9 r0 *1 0,0
Rvdd_t9 vdd__t9 vdd 18.1330333773
* device instance vdd_t10 r0 *1 0,0
Rvdd_t10 vdd__t10 vdd 13.45811671
* device instance vdd_t11 r0 *1 0,0
Rvdd_t11 vdd__t11 vdd 19.4858569623
* device instance vdd_t12 r0 *1 0,0
Rvdd_t12 vdd__t12 vdd 18.1330333773
* device instance vdd_t13 r0 *1 0,0
Rvdd_t13 vdd__t13 vdd 13.45811671
* device instance vdd_t14 r0 *1 0,0
Rvdd_t14 vdd__t14 vdd 12.7517222309
* device instance vdd_t15 r0 *1 0,0
Rvdd_t15 vdd__t15 vdd 12.0153449899
* device instance vdd_t16 r0 *1 0,0
Rvdd_t16 vdd__t16 vdd 5.06293985454
* device instance vdd_t17 r0 *1 0,0
Rvdd_t17 vdd__t17 vdd 30.6467021546
* device instance vdd_t18 r0 *1 0,0
Rvdd_t18 vdd__t18 vdd 5.79931608306
* device instance vdd_t19 r0 *1 0,0
Rvdd_t19 vdd__t19 vdd 12.7517222309
* device instance vdd_t20 r0 *1 0,0
Rvdd_t20 vdd__t20 vdd 12.0153449899
* device instance vdd_t21 r0 *1 0,0
Rvdd_t21 vdd__t21 vdd 5.06293985454
* device instance vdd_t22 r0 *1 0,0
Rvdd_t22 vdd__t22 vdd 30.6467021546
* device instance vdd_t23 r0 *1 0,0
Rvdd_t23 vdd__t23 vdd 5.79931608306
* device instance vdd r0 *1 0,0
Cvdd vdd vsubs 1.20306106e-13
* device instance vss_t0 r0 *1 0,0
Rvss_t0 vss__t0 vss 42.0101420443
* device instance vss_t1 r0 *1 0,0
Rvss_t1 vss__t1 vss 37.6596471854
* device instance vss_t2 r0 *1 0,0
Rvss_t2 vss__t2 vss 34.0451769911
* device instance vss_t3 r0 *1 0,0
Rvss_t3 vss__t3 vss 2.71652078081
* device instance vss_t4 r0 *1 0,0
Rvss_t4 vss__t4 vss 13.0466276487
* device instance vss_t5 r0 *1 0,0
Rvss_t5 vss__t5 vss 20.7216563825
* device instance vss_t6 r0 *1 0,0
Rvss_t6 vss__t6 vss 7.6014624196
* device instance vss_t7 r0 *1 0,0
Rvss_t7 vss__t7 vss 0.8074703853
* device instance vss_t8 r0 *1 0,0
Rvss_t8 vss__t8 vss 6.43648502149
* device instance vss_t9 r0 *1 0,0
Rvss_t9 vss__t9 vss 0.358121970092
* device instance vss_t10 r0 *1 0,0
Rvss_t10 vss__t10 vss 9.50898537689
* device instance vss_t11 r0 *1 0,0
Rvss_t11 vss__t11 vss 13.6389542999
* device instance vss_t12 r0 *1 0,0
Rvss_t12 vss__t12 vss 14.2647885612
* device instance vss_t13 r0 *1 0,0
Rvss_t13 vss__t13 vss 14.8906245648
* device instance vss_t14 r0 *1 0,0
Rvss_t14 vss__t14 vss 15.5164620998
* device instance vss_t15 r0 *1 0,0
Rvss_t15 vss__t15 vss 48.4960419524
* device instance vss_t16 r0 *1 0,0
Rvss_t16 vss__t16 vss 0.192063498166
* device instance vss_t17 r0 *1 0,0
Rvss_t17 vss__t17 vss 7.26861161636
* device instance vss_t18 r0 *1 0,0
Rvss_t18 vss__t18 vss 6.93576090077
* device instance vss_t19 r0 *1 0,0
Rvss_t19 vss__t19 vss 6.60291028609
* device instance vss_t20 r0 *1 0,0
Rvss_t20 vss__t20 vss 0.142645956343
* device instance vss_t21 r0 *1 0,0
Rvss_t21 vss__t21 vss 0.474750335226
* device instance vss_t22 r0 *1 0,0
Rvss_t22 vss__t22 vss 0.0303407612646
* device instance vss_t23 r0 *1 0,0
Rvss_t23 vss__t23 vss 7.10218624683
* device instance vss_t24 r0 *1 0,0
Rvss_t24 vss__t24 vss 6.76933557988
* device instance vss_t25 r0 *1 0,0
Rvss_t25 vss__t25 vss 0.641093273765
* device instance vss_t26 r0 *1 0,0
Rvss_t26 vss__t26 vss 0.308496853353
* device instance vss_t27 r0 *1 0,0
Rvss_t27 vss__t27 vss 7.43503700776
* device instance vss r0 *1 0,0
Cvss vss vsubs 8.3929007e-14
* device instance cc__1__18 r0 *1 0,0
Ccc__1__18 \$1 \$18 1.0412e-17
* device instance cc__1__19 r0 *1 0,0
Ccc__1__19 \$1 \$19 1.0412e-17
* device instance cc__11__12 r0 *1 0,0
Ccc__11__12 \$11 \$12 1.0412e-17
* device instance cc__11__14 r0 *1 0,0
Ccc__11__14 \$11 \$14 2.0825e-17
* device instance cc__11__18 r0 *1 0,0
Ccc__11__18 \$11 \$18 2.0825e-17
* device instance cc__11__29 r0 *1 0,0
Ccc__11__29 \$11 \$29 1.0412e-17
* device instance cc__11_t0 r0 *1 0,0
Ccc__11_t0 \$11 t0 1.0412e-17
* device instance cc__11_t1 r0 *1 0,0
Ccc__11_t1 \$11 t1 1.0412e-17
* device instance cc__11_t2 r0 *1 0,0
Ccc__11_t2 \$11 t2 1.0412e-17
* device instance cc__11_t3 r0 *1 0,0
Ccc__11_t3 \$11 t3 1.0412e-17
* device instance cc__11_t4 r0 *1 0,0
Ccc__11_t4 \$11 t4 1.0412e-17
* device instance cc__11_t5 r0 *1 0,0
Ccc__11_t5 \$11 t5 1.0412e-17
* device instance cc__11_t6 r0 *1 0,0
Ccc__11_t6 \$11 t6 1.0412e-17
* device instance cc__11_t7 r0 *1 0,0
Ccc__11_t7 \$11 t7 1.0412e-17
* device instance cc__11_vdd r0 *1 0,0
Ccc__11_vdd \$11 vdd 2.0825e-17
* device instance cc__11_vss r0 *1 0,0
Ccc__11_vss \$11 vss 3.1237e-17
* device instance cc__12__14 r0 *1 0,0
Ccc__12__14 \$12 \$14 2.0825e-17
* device instance cc__12__15 r0 *1 0,0
Ccc__12__15 \$12 \$15 1.0412e-17
* device instance cc__12__18 r0 *1 0,0
Ccc__12__18 \$12 \$18 5.2062e-17
* device instance cc__12__19 r0 *1 0,0
Ccc__12__19 \$12 \$19 1.0412e-17
* device instance cc__12__31 r0 *1 0,0
Ccc__12__31 \$12 \$31 1.0412e-17
* device instance cc__12_t0 r0 *1 0,0
Ccc__12_t0 \$12 t0 1.0412e-17
* device instance cc__12_t1 r0 *1 0,0
Ccc__12_t1 \$12 t1 1.0412e-17
* device instance cc__12_t2 r0 *1 0,0
Ccc__12_t2 \$12 t2 1.0412e-17
* device instance cc__12_t3 r0 *1 0,0
Ccc__12_t3 \$12 t3 1.0412e-17
* device instance cc__12_t4 r0 *1 0,0
Ccc__12_t4 \$12 t4 1.0412e-17
* device instance cc__12_t5 r0 *1 0,0
Ccc__12_t5 \$12 t5 1.0412e-17
* device instance cc__12_t6 r0 *1 0,0
Ccc__12_t6 \$12 t6 1.0412e-17
* device instance cc__12_t7 r0 *1 0,0
Ccc__12_t7 \$12 t7 1.0412e-17
* device instance cc__12_vdd r0 *1 0,0
Ccc__12_vdd \$12 vdd 3.1237e-17
* device instance cc__12_vss r0 *1 0,0
Ccc__12_vss \$12 vss 8.3299e-17
* device instance cc__14__15 r0 *1 0,0
Ccc__14__15 \$14 \$15 3.1237e-17
* device instance cc__14__16 r0 *1 0,0
Ccc__14__16 \$14 \$16 3.1237e-17
* device instance cc__14__17 r0 *1 0,0
Ccc__14__17 \$14 \$17 5.2062e-17
* device instance cc__14__18 r0 *1 0,0
Ccc__14__18 \$14 \$18 2.0825e-17
* device instance cc__14__28 r0 *1 0,0
Ccc__14__28 \$14 \$28 1.0412e-17
* device instance cc__14__32 r0 *1 0,0
Ccc__14__32 \$14 \$32 1.0412e-17
* device instance cc__14__34 r0 *1 0,0
Ccc__14__34 \$14 \$34 2.0825e-17
* device instance cc__14__35 r0 *1 0,0
Ccc__14__35 \$14 \$35 2.0825e-17
* device instance cc__14_clk r0 *1 0,0
Ccc__14_clk \$14 clk 6.2474e-17
* device instance cc__14_vdd r0 *1 0,0
Ccc__14_vdd \$14 vdd 5.2062e-17
* device instance cc__14_vss r0 *1 0,0
Ccc__14_vss \$14 vss 2.89396e-16
* device instance cc__15__16 r0 *1 0,0
Ccc__15__16 \$15 \$16 2.0825e-17
* device instance cc__15__17 r0 *1 0,0
Ccc__15__17 \$15 \$17 3.1237e-17
* device instance cc__15__18 r0 *1 0,0
Ccc__15__18 \$15 \$18 1.0412e-17
* device instance cc__15__29 r0 *1 0,0
Ccc__15__29 \$15 \$29 1.0412e-17
* device instance cc__15__30 r0 *1 0,0
Ccc__15__30 \$15 \$30 1.0412e-17
* device instance cc__15_clk r0 *1 0,0
Ccc__15_clk \$15 clk 4.1649e-17
* device instance cc__15_vdd r0 *1 0,0
Ccc__15_vdd \$15 vdd 6.2474e-17
* device instance cc__15_vss r0 *1 0,0
Ccc__15_vss \$15 vss 6.2474e-17
* device instance cc__16__17 r0 *1 0,0
Ccc__16__17 \$16 \$17 4.1649e-17
* device instance cc__16__32 r0 *1 0,0
Ccc__16__32 \$16 \$32 1.0412e-17
* device instance cc__16__33 r0 *1 0,0
Ccc__16__33 \$16 \$33 1.0412e-17
* device instance cc__16__34 r0 *1 0,0
Ccc__16__34 \$16 \$34 2.0825e-17
* device instance cc__16_clk r0 *1 0,0
Ccc__16_clk \$16 clk 5.2062e-17
* device instance cc__16_vdd r0 *1 0,0
Ccc__16_vdd \$16 vdd 6.2474e-17
* device instance cc__16_vss r0 *1 0,0
Ccc__16_vss \$16 vss 5.2062e-17
* device instance cc__17_clk r0 *1 0,0
Ccc__17_clk \$17 clk 4.1649e-17
* device instance cc__17_vdd r0 *1 0,0
Ccc__17_vdd \$17 vdd 2.0825e-17
* device instance cc__17_vss r0 *1 0,0
Ccc__17_vss \$17 vss 3.1237e-17
* device instance cc__18_t0 r0 *1 0,0
Ccc__18_t0 \$18 t0 1.0412e-17
* device instance cc__18_t1 r0 *1 0,0
Ccc__18_t1 \$18 t1 1.0412e-17
* device instance cc__18_t2 r0 *1 0,0
Ccc__18_t2 \$18 t2 1.0412e-17
* device instance cc__18_t3 r0 *1 0,0
Ccc__18_t3 \$18 t3 1.0412e-17
* device instance cc__18_t4 r0 *1 0,0
Ccc__18_t4 \$18 t4 1.0412e-17
* device instance cc__18_t5 r0 *1 0,0
Ccc__18_t5 \$18 t5 1.0412e-17
* device instance cc__18_t6 r0 *1 0,0
Ccc__18_t6 \$18 t6 1.0412e-17
* device instance cc__18_t7 r0 *1 0,0
Ccc__18_t7 \$18 t7 1.0412e-17
* device instance cc__18_vdd r0 *1 0,0
Ccc__18_vdd \$18 vdd 5.2062e-17
* device instance cc__18_vss r0 *1 0,0
Ccc__18_vss \$18 vss 7.2887e-17
* device instance cc__19_vdd r0 *1 0,0
Ccc__19_vdd \$19 vdd 2.0825e-17
* device instance cc__19_vss r0 *1 0,0
Ccc__19_vss \$19 vss 2.0825e-17
* device instance cc__28__29 r0 *1 0,0
Ccc__28__29 \$28 \$29 1.0412e-17
* device instance cc__29__30 r0 *1 0,0
Ccc__29__30 \$29 \$30 1.0412e-17
* device instance cc__29_vdd r0 *1 0,0
Ccc__29_vdd \$29 vdd 3.1237e-17
* device instance cc__29_vss r0 *1 0,0
Ccc__29_vss \$29 vss 1.0412e-17
* device instance cc__30_vdd r0 *1 0,0
Ccc__30_vdd \$30 vdd 2.0825e-17
* device instance cc__30_vss r0 *1 0,0
Ccc__30_vss \$30 vss 1.0412e-17
* device instance cc__31__32 r0 *1 0,0
Ccc__31__32 \$31 \$32 1.0412e-17
* device instance cc__32__33 r0 *1 0,0
Ccc__32__33 \$32 \$33 1.0412e-17
* device instance cc__32_vdd r0 *1 0,0
Ccc__32_vdd \$32 vdd 3.1237e-17
* device instance cc__32_vss r0 *1 0,0
Ccc__32_vss \$32 vss 1.0412e-17
* device instance cc__33_vdd r0 *1 0,0
Ccc__33_vdd \$33 vdd 2.0825e-17
* device instance cc__33_vss r0 *1 0,0
Ccc__33_vss \$33 vss 1.0412e-17
* device instance cc_clk_vdd r0 *1 0,0
Ccc_clk_vdd clk vdd 3.1237e-17
* device instance cc_clk_vss r0 *1 0,0
Ccc_clk_vss clk vss 5.2062e-17
* device instance cc_t0_vdd r0 *1 0,0
Ccc_t0_vdd t0 vdd 1.0412e-17
* device instance cc_t0_vss r0 *1 0,0
Ccc_t0_vss t0 vss 1.0412e-17
* device instance cc_t1_vdd r0 *1 0,0
Ccc_t1_vdd t1 vdd 1.0412e-17
* device instance cc_t1_vss r0 *1 0,0
Ccc_t1_vss t1 vss 1.0412e-17
* device instance cc_t2_vdd r0 *1 0,0
Ccc_t2_vdd t2 vdd 1.0412e-17
* device instance cc_t2_vss r0 *1 0,0
Ccc_t2_vss t2 vss 1.0412e-17
* device instance cc_t3_vdd r0 *1 0,0
Ccc_t3_vdd t3 vdd 1.0412e-17
* device instance cc_t3_vss r0 *1 0,0
Ccc_t3_vss t3 vss 1.0412e-17
* device instance cc_t4_vdd r0 *1 0,0
Ccc_t4_vdd t4 vdd 1.0412e-17
* device instance cc_t4_vss r0 *1 0,0
Ccc_t4_vss t4 vss 1.0412e-17
* device instance cc_t5_vdd r0 *1 0,0
Ccc_t5_vdd t5 vdd 1.0412e-17
* device instance cc_t5_vss r0 *1 0,0
Ccc_t5_vss t5 vss 1.0412e-17
* device instance cc_t6_vdd r0 *1 0,0
Ccc_t6_vdd t6 vdd 1.0412e-17
* device instance cc_t6_vss r0 *1 0,0
Ccc_t6_vss t6 vss 1.0412e-17
* device instance cc_t7_vdd r0 *1 0,0
Ccc_t7_vdd t7 vdd 1.0412e-17
* device instance cc_t7_vss r0 *1 0,0
Ccc_t7_vss t7 vss 1.0412e-17
* device instance cc_vdd_vss r0 *1 0,0
Ccc_vdd_vss vdd vss 1.24948e-16
* device instance vsubs_dctie r0 *1 0,0
Rvsubs_dctie vsubs 0 1e+12
.ENDS rcosc_top
