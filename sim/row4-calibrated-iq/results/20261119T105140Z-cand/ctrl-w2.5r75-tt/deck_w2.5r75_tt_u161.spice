* row4 calibrated-Iq control deck: w2.5r75 tt u161 code 166 (generated by sim/row4-calibrated-iq/gen.py; DUT = sim/cmph-fix/rcosc_top_p3_cmphfix.spice, the DR-0044 L=1um control; seed = candidate die's derived rndseed)
.options seed=1780379916
* candidate die bookkeeping: sample_index=161 process_seed=1896205814 mismatch_seed=1675662898
.param sw_stat_global=0 sw_stat_mismatch=1 mc_skew=3 res_mc_skew=3 cap_mc_skew=3 fnoicor=0 mm_scale=1
.lib $PDK_ROOT/gf180mcuC/libs.tech/ngspice/sm141064.ngspice typical
.lib $PDK_ROOT/gf180mcuC/libs.tech/ngspice/sm141064.ngspice res_typical
.lib $PDK_ROOT/gf180mcuC/libs.tech/ngspice/sm141064.ngspice mimcap_typical
.lib $PDK_ROOT/gf180mcuC/libs.tech/ngspice/sm141064.ngspice cap_mim
* DR-0022 section 4 injected mismatch (flagged assumption; no evidence)
.param mm_scale=1
.param d_ctiming='sw_stat_mismatch*agauss(0,0.0007071067811865475,1)'
.param d__87='sw_stat_mismatch*agauss(0,0.0007071067811865476,1)'
.param d__88='sw_stat_mismatch*agauss(0,0.0007071067811865476,1)'
.param d__89='sw_stat_mismatch*agauss(0,0.0007071067811865476,1)'
.param d__90='sw_stat_mismatch*agauss(0,0.00125,1)'
.param d__91='sw_stat_mismatch*agauss(0,0.0020379663547086,1)'
.param d__92='sw_stat_mismatch*agauss(0,0.009772038812426304,1)'
.param d__93='sw_stat_mismatch*agauss(0,0.00690756661728224,1)'
.param d__94='sw_stat_mismatch*agauss(0,0.004885203096892241,1)'
.param d__95='sw_stat_mismatch*agauss(0,0.0034543602372860264,1)'
.param d__96='sw_stat_mismatch*agauss(0,0.0024426015484461205,1)'
.param d__97='sw_stat_mismatch*agauss(0,0.0017271801186430132,1)'
.param d__98='sw_stat_mismatch*agauss(0,0.0012213007742230603,1)'
.param d__99='sw_stat_mismatch*agauss(0,0.0008635945677412671,1)'
.SUBCKT rcosc_top vdd vss clk t0 t1 t2 t3 t4 t5 t6 t7
* device instance $1 r0 *1 317.05,1 nfet
X$1 \$35__t0 \$35__t1 vss__t0 vsubs nfet_03v3 L=1U W=2U AS=0.84P AD=0.84P PS=4.84U PD=4.84U
* device instance $2 r0 *1 385.01,1 nfet
X$2 \$7__t0 \$6__t0 vss__t2 vsubs nfet_03v3 L=20U W=2U AS=0.84P AD=0.84P PS=4.84U PD=4.84U
* device instance $3 r0 *1 448.146,12 nfet
X$3 \$8__t2 t0__t0 \$9__t1 vsubs nfet_03v3 L=0.28U W=24U AS=10.08P AD=10.08P PS=48.84U PD=48.84U
* device instance $4 r0 *1 453.376,1 nfet
X$4 \$11__t0 t0__t1 vss__t3 vsubs nfet_03v3 L=0.5U W=2U AS=0.84P AD=0.84P PS=4.84U PD=4.84U
* device instance $5 r0 *1 464.943,8 nfet
X$5 \$9__t3 t1__t0 \$12__t1 vsubs nfet_03v3 L=0.28U W=16U AS=6.72P AD=6.72P PS=32.84U PD=32.84U
* device instance $6 r0 *1 470.173,1 nfet
X$6 \$13__t2 t1__t2 vss__t15 vsubs nfet_03v3 L=0.5U W=2U AS=0.84P AD=0.84P PS=4.84U PD=4.84U
* device instance $7 r0 *1 483.236,6 nfet
X$7 \$12__t3 t2__t0 \$14__t1 vsubs nfet_03v3 L=0.28U W=12U AS=5.04P AD=5.04P PS=24.84U PD=24.84U
* device instance $8 r0 *1 488.466,1 nfet
X$8 \$15__t2 t2__t2 vss__t12 vsubs nfet_03v3 L=0.5U W=2U AS=0.84P AD=0.84P PS=4.84U PD=4.84U
* device instance $9 r0 *1 504.522,4 nfet
X$9 \$14__t3 t3__t0 \$16__t1 vsubs nfet_03v3 L=0.28U W=8U AS=3.36P AD=3.36P PS=16.84U PD=16.84U
* device instance $10 r0 *1 509.752,1 nfet
X$10 \$17__t2 t3__t2 vss__t14 vsubs nfet_03v3 L=0.5U W=2U AS=0.84P AD=0.84P PS=4.84U PD=4.84U
* device instance $11 r0 *1 531.794,3 nfet
X$11 \$16__t3 t4__t0 \$18__t1 vsubs nfet_03v3 L=0.28U W=6U AS=2.52P AD=2.52P PS=12.84U PD=12.84U
* device instance $12 r0 *1 537.024,1 nfet
X$12 \$19__t2 t4__t2 vss__t13 vsubs nfet_03v3 L=0.5U W=2U AS=0.84P AD=0.84P PS=4.84U PD=4.84U
* device instance $13 r0 *1 571.038,2.5 nfet
X$13 \$18__t3 t5__t0 \$20__t1 vsubs nfet_03v3 L=0.28U W=5U AS=2.1P AD=2.1P PS=10.84U PD=10.84U
* device instance $14 r0 *1 576.268,1 nfet
X$14 \$21__t2 t5__t2 vss__t16 vsubs nfet_03v3 L=0.5U W=2U AS=0.84P AD=0.84P PS=4.84U PD=4.84U
* device instance $15 r0 *1 634.226,2 nfet
X$15 \$20__t3 t6__t0 \$22__t1 vsubs nfet_03v3 L=0.28U W=4U AS=1.68P AD=1.68P PS=8.84U PD=8.84U
* device instance $16 r0 *1 639.456,1 nfet
X$16 \$23__t2 t6__t2 vss__t17 vsubs nfet_03v3 L=0.5U W=2U AS=0.84P AD=0.84P PS=4.84U PD=4.84U
* device instance $17 r0 *1 745.301,1.5 nfet
X$17 \$22__t3 t7__t0 \$24__t1 vsubs nfet_03v3 L=0.28U W=3U AS=1.26P AD=1.26P PS=6.84U PD=6.84U
* device instance $18 r0 *1 750.531,1 nfet
X$18 \$25__t2 t7__t2 vss__t18 vsubs nfet_03v3 L=0.5U W=2U AS=0.84P AD=0.84P PS=4.84U PD=4.84U
* device instance $19 r0 *1 868.381,2 nfet
X$19 \$42__t0 \$24__t3 \$27__t0 vsubs nfet_03v3 L=0.5U W=4U AS=1.68P AD=1.68P PS=8.84U PD=8.84U
* device instance $20 r0 *1 873.721,2 nfet
X$20 \$28__t0 \$5__t1 \$27__t1 vsubs nfet_03v3 L=0.5U W=4U AS=1.68P AD=1.68P PS=8.84U PD=8.84U
* device instance $21 r0 *1 879.061,0.5 nfet
X$21 \$29__t0 \$42__t1 vss__t4 vsubs nfet_03v3 L=0.5U W=1U AS=0.42P AD=0.42P PS=2.84U PD=2.84U
* device instance $22 r0 *1 910.821,2 nfet
X$22 \$43__t0 \$43__t1 vss__t5 vsubs nfet_03v3 L=1U W=4U AS=1.68P AD=1.68P PS=8.84U PD=8.84U
* device instance $23 r0 *1 916.661,2 nfet
X$23 \$30__t1 \$43__t2 vss__t11 vsubs nfet_03v3 L=1U W=4U AS=1.68P AD=1.68P PS=8.84U PD=8.84U
* device instance $24 r0 *1 922.251,0.25 nfet
X$24 \$31__t0 \$30__t0 vss__t6 vsubs nfet_03v3 L=0.5U W=0.5U AS=0.21P AD=0.21P PS=1.84U PD=1.84U
* device instance $25 r0 *1 927.591,1 nfet
X$25 \$32__t2 \$31__t3 vss__t19 vsubs nfet_03v3 L=0.5U W=2U AS=0.84P AD=0.84P PS=4.84U PD=4.84U
* device instance $26 r0 *1 978.051,10 nfet
X$26 \$24__t4 clk__t0 vss__t7 vsubs nfet_03v3 L=0.5U W=20U AS=8.4P AD=8.4P PS=40.84U PD=40.84U
* device instance $27 r0 *1 983.391,1 nfet
X$27 \$33__t3 \$29__t3 vss__t23 vsubs nfet_03v3 L=0.5U W=2U AS=0.84P AD=0.84P PS=4.84U PD=4.84U
* device instance $28 r0 *1 988.731,1 nfet
X$28 \$33__t2 clk__t5 vss__t20 vsubs nfet_03v3 L=0.5U W=2U AS=0.84P AD=0.84P PS=4.84U PD=4.84U
* device instance $29 r0 *1 994.071,1 nfet
X$29 clk__t3 \$32__t3 vss__t21 vsubs nfet_03v3 L=0.5U W=2U AS=0.84P AD=0.84P PS=4.84U PD=4.84U
* device instance $30 r0 *1 999.411,1 nfet
X$30 clk__t4 \$33__t4 vss__t22 vsubs nfet_03v3 L=0.5U W=2U AS=0.84P AD=0.84P PS=4.84U PD=4.84U
* device instance $31 r0 *1 322.89,1.82 nfet
X$31 \$7__t12 \$35__t3 \$1__t1 vsubs nfet_03v3 L=1U W=2U AS=0.84P AD=0.42P PS=4.84U PD=2.42U
* device instance $32 r0 *1 324.31,1.82 nfet
X$32 \$1__t6 \$35__t4 \$7__t13 vsubs nfet_03v3 L=1U W=2U AS=0.42P AD=0.42P PS=2.42U PD=2.42U
* device instance $33 r0 *1 325.73,1.82 nfet
X$33 \$7__t8 \$35__t7 \$1__t5 vsubs nfet_03v3 L=1U W=2U AS=0.42P AD=0.42P PS=2.42U PD=2.42U
* device instance $34 r0 *1 327.15,1.82 nfet
X$34 \$1__t3 \$35__t8 \$7__t14 vsubs nfet_03v3 L=1U W=2U AS=0.42P AD=0.42P PS=2.42U PD=2.42U
* device instance $35 r0 *1 328.57,1.82 nfet
X$35 \$7__t9 \$35__t9 \$1__t7 vsubs nfet_03v3 L=1U W=2U AS=0.42P AD=0.42P PS=2.42U PD=2.42U
* device instance $36 r0 *1 329.99,1.82 nfet
X$36 \$1__t4 \$35__t10 \$7__t15 vsubs nfet_03v3 L=1U W=2U AS=0.42P AD=0.42P PS=2.42U PD=2.42U
* device instance $37 r0 *1 331.41,1.82 nfet
X$37 \$7__t10 \$35__t11 \$1__t8 vsubs nfet_03v3 L=1U W=2U AS=0.42P AD=0.42P PS=2.42U PD=2.42U
* device instance $38 r0 *1 332.83,1.82 nfet
X$38 \$1__t2 \$35__t5 \$7__t11 vsubs nfet_03v3 L=1U W=2U AS=0.42P AD=0.84P PS=2.42U PD=4.84U
* device instance $39 r0 *1 852.851,1.82 nfet
X$39 \$27__t9 \$35__t18 vss__t10 vsubs nfet_03v3 L=1U W=2U AS=0.84P AD=0.42P PS=4.84U PD=2.42U
* device instance $40 r0 *1 854.271,1.82 nfet
X$40 vss__t25 \$35__t12 \$27__t6 vsubs nfet_03v3 L=1U W=2U AS=0.42P AD=0.42P PS=2.42U PD=2.42U
* device instance $41 r0 *1 855.691,1.82 nfet
X$41 \$27__t3 \$35__t13 vss__t28 vsubs nfet_03v3 L=1U W=2U AS=0.42P AD=0.42P PS=2.42U PD=2.42U
* device instance $42 r0 *1 857.111,1.82 nfet
X$42 vss__t26 \$35__t14 \$27__t7 vsubs nfet_03v3 L=1U W=2U AS=0.42P AD=0.42P PS=2.42U PD=2.42U
* device instance $43 r0 *1 858.531,1.82 nfet
X$43 \$27__t4 \$35__t15 vss__t29 vsubs nfet_03v3 L=1U W=2U AS=0.42P AD=0.42P PS=2.42U PD=2.42U
* device instance $44 r0 *1 859.951,1.82 nfet
X$44 vss__t27 \$35__t16 \$27__t8 vsubs nfet_03v3 L=1U W=2U AS=0.42P AD=0.42P PS=2.42U PD=2.42U
* device instance $45 r0 *1 861.371,1.82 nfet
X$45 \$27__t5 \$35__t17 vss__t30 vsubs nfet_03v3 L=1U W=2U AS=0.42P AD=0.42P PS=2.42U PD=2.42U
* device instance $46 r0 *1 862.791,1.82 nfet
X$46 vss__t9 \$35__t6 \$27__t2 vsubs nfet_03v3 L=1U W=2U AS=0.42P AD=0.84P PS=2.42U PD=4.84U
* device instance $47 r0 *1 400.5,2 pfet
X$47 \$7__t7 \$7__t1 vdd__t1 vdd__t2 pfet_03v3 L=1U W=4U AS=1.68P AD=1.68P PS=8.84U PD=8.84U
* device instance $48 r0 *1 406.64,2 pfet
X$48 \$35__t2 \$7__t6 vdd__t59 vdd__t56 pfet_03v3 L=1U W=4U AS=1.68P AD=1.68P PS=8.84U PD=8.84U
* device instance $49 r0 *1 755.911,12 pfet
X$49 \$9__t4 \$11__t1 \$8__t3 vdd__t4 pfet_03v3 L=0.28U W=24U AS=10.08P AD=10.08P PS=48.84U PD=48.84U
* device instance $50 r0 *1 761.331,8 pfet
X$50 \$12__t4 \$13__t0 \$9__t5 vdd__t5 pfet_03v3 L=0.28U W=16U AS=6.72P AD=6.72P PS=32.84U PD=32.84U
* device instance $51 r0 *1 766.751,6 pfet
X$51 \$14__t4 \$15__t0 \$12__t5 vdd__t6 pfet_03v3 L=0.28U W=12U AS=5.04P AD=5.04P PS=24.84U PD=24.84U
* device instance $52 r0 *1 772.171,4 pfet
X$52 \$16__t4 \$17__t0 \$14__t5 vdd__t7 pfet_03v3 L=0.28U W=8U AS=3.36P AD=3.36P PS=16.84U PD=16.84U
* device instance $53 r0 *1 777.591,3 pfet
X$53 \$18__t4 \$19__t0 \$16__t5 vdd__t8 pfet_03v3 L=0.28U W=6U AS=2.52P AD=2.52P PS=12.84U PD=12.84U
* device instance $54 r0 *1 783.011,2.5 pfet
X$54 \$20__t4 \$21__t0 \$18__t5 vdd__t9 pfet_03v3 L=0.28U W=5U AS=2.1P AD=2.1P PS=10.84U PD=10.84U
* device instance $55 r0 *1 788.431,2 pfet
X$55 \$22__t4 \$23__t0 \$20__t5 vdd__t10 pfet_03v3 L=0.28U W=4U AS=1.68P AD=1.68P PS=8.84U PD=8.84U
* device instance $56 r0 *1 793.851,1.5 pfet
X$56 \$24__t2 \$25__t0 \$22__t5 vdd__t11 pfet_03v3 L=0.28U W=3U AS=1.26P AD=1.26P PS=6.84U PD=6.84U
* device instance $57 r0 *1 799.381,2 pfet
X$57 \$11__t2 t0__t2 vdd__t12 vdd__t13 pfet_03v3 L=0.5U W=4U AS=1.68P AD=1.68P PS=8.84U PD=8.84U
* device instance $58 r0 *1 805.021,2 pfet
X$58 \$13__t1 t1__t1 vdd__t53 vdd__t41 pfet_03v3 L=0.5U W=4U AS=1.68P AD=1.68P PS=8.84U PD=8.84U
* device instance $59 r0 *1 810.661,2 pfet
X$59 \$15__t1 t2__t1 vdd__t42 vdd__t28 pfet_03v3 L=0.5U W=4U AS=1.68P AD=1.68P PS=8.84U PD=8.84U
* device instance $60 r0 *1 816.301,2 pfet
X$60 \$17__t1 t3__t1 vdd__t43 vdd__t29 pfet_03v3 L=0.5U W=4U AS=1.68P AD=1.68P PS=8.84U PD=8.84U
* device instance $61 r0 *1 821.941,2 pfet
X$61 \$19__t1 t4__t1 vdd__t44 vdd__t30 pfet_03v3 L=0.5U W=4U AS=1.68P AD=1.68P PS=8.84U PD=8.84U
* device instance $62 r0 *1 827.581,2 pfet
X$62 \$21__t1 t5__t1 vdd__t45 vdd__t31 pfet_03v3 L=0.5U W=4U AS=1.68P AD=1.68P PS=8.84U PD=8.84U
* device instance $63 r0 *1 833.221,2 pfet
X$63 \$23__t1 t6__t1 vdd__t46 vdd__t32 pfet_03v3 L=0.5U W=4U AS=1.68P AD=1.68P PS=8.84U PD=8.84U
* device instance $64 r0 *1 838.861,2 pfet
X$64 \$25__t1 t7__t1 vdd__t47 vdd__t33 pfet_03v3 L=0.5U W=4U AS=1.68P AD=1.68P PS=8.84U PD=8.84U
* device instance $65 r0 *1 884.801,2 pfet
X$65 \$28__t3 \$28__t1 vdd__t57 vdd__t54 pfet_03v3 L=1U W=4U AS=1.68P AD=1.68P PS=8.84U PD=8.84U
* device instance $66 r0 *1 890.941,2 pfet
X$66 \$42__t3 \$28__t2 vdd__t58 vdd__t55 pfet_03v3 L=1U W=4U AS=1.68P AD=1.68P PS=8.84U PD=8.84U
* device instance $67 r0 *1 896.831,2 pfet
X$67 \$29__t2 \$42__t2 vdd__t48 vdd__t34 pfet_03v3 L=0.5U W=4U AS=1.68P AD=1.68P PS=8.84U PD=8.84U
* device instance $68 r0 *1 960.281,2 pfet
X$68 \$31__t2 \$30__t2 vdd__t49 vdd__t35 pfet_03v3 L=0.5U W=4U AS=1.68P AD=1.68P PS=8.84U PD=8.84U
* device instance $69 r0 *1 965.921,2 pfet
X$69 \$32__t1 \$31__t1 vdd__t50 vdd__t36 pfet_03v3 L=0.5U W=4U AS=1.68P AD=1.68P PS=8.84U PD=8.84U
* device instance $70 r0 *1 1004.901,2 pfet
X$70 \$45__t1 \$29__t1 vdd__t51 vdd__t37 pfet_03v3 L=0.5U W=4U AS=1.68P AD=1.68P PS=8.84U PD=8.84U
* device instance $71 r0 *1 1010.541,2 pfet
X$71 \$33__t1 clk__t1 \$45__t0 vdd__t38 pfet_03v3 L=0.5U W=4U AS=1.68P AD=1.68P PS=8.84U PD=8.84U
* device instance $72 r0 *1 1016.181,2 pfet
X$72 \$34__t1 \$32__t0 vdd__t52 vdd__t39 pfet_03v3 L=0.5U W=4U AS=1.68P AD=1.68P PS=8.84U PD=8.84U
* device instance $73 r0 *1 1021.821,2 pfet
X$73 clk__t2 \$33__t0 \$34__t0 vdd__t40 pfet_03v3 L=0.5U W=4U AS=1.68P AD=1.68P PS=8.84U PD=8.84U
* device instance $74 r0 *1 933.331,2.82 pfet
X$74 \$4__t10 \$7__t2 vdd__t14 vdd__t15 pfet_03v3 L=1U W=4U AS=1.68P AD=0.84P PS=8.84U PD=4.42U
* device instance $75 r0 *1 934.751,2.82 pfet
X$75 vdd__t61 \$7__t3 \$4__t11 vdd__t16 pfet_03v3 L=1U W=4U AS=0.84P AD=0.84P PS=4.42U PD=4.42U
* device instance $76 r0 *1 936.171,2.82 pfet
X$76 \$4__t8 \$7__t5 vdd__t60 vdd__t27 pfet_03v3 L=1U W=4U AS=0.84P AD=0.84P PS=4.42U PD=4.42U
* device instance $77 r0 *1 937.591,2.82 pfet
X$77 vdd__t17 \$7__t4 \$4__t9 vdd__t18 pfet_03v3 L=1U W=4U AS=0.84P AD=1.68P PS=4.42U PD=8.84U
* device instance $78 r0 *1 943.481,1.82 pfet
X$78 \$43__t5 \$6__t4 \$4__t0 vdd__t19 pfet_03v3 L=0.5U W=2U AS=0.84P AD=0.42P PS=4.84U PD=2.42U
* device instance $79 r0 *1 944.401,1.82 pfet
X$79 \$4__t7 \$6__t3 \$43__t6 vdd__t20 pfet_03v3 L=0.5U W=2U AS=0.42P AD=0.42P PS=2.42U PD=2.42U
* device instance $80 r0 *1 945.321,1.82 pfet
X$80 \$43__t3 \$6__t2 \$4__t6 vdd__t25 pfet_03v3 L=0.5U W=2U AS=0.42P AD=0.42P PS=2.42U PD=2.42U
* device instance $81 r0 *1 946.241,1.82 pfet
X$81 \$4__t1 \$6__t1 \$43__t4 vdd__t21 pfet_03v3 L=0.5U W=2U AS=0.42P AD=0.84P PS=2.42U PD=4.84U
* device instance $82 r0 *1 951.881,1.82 pfet
X$82 \$30__t6 \$24__t5 \$4__t3 vdd__t26 pfet_03v3 L=0.5U W=2U AS=0.84P AD=0.42P PS=4.84U PD=2.42U
* device instance $83 r0 *1 952.801,1.82 pfet
X$83 \$4__t4 \$24__t6 \$30__t5 vdd__t24 pfet_03v3 L=0.5U W=2U AS=0.42P AD=0.42P PS=2.42U PD=2.42U
* device instance $84 r0 *1 953.721,1.82 pfet
X$84 \$30__t4 \$24__t9 \$4__t5 vdd__t23 pfet_03v3 L=0.5U W=2U AS=0.42P AD=0.42P PS=2.42U PD=2.42U
* device instance $85 r0 *1 954.641,1.82 pfet
X$85 \$4__t2 \$24__t7 \$30__t3 vdd__t22 pfet_03v3 L=0.5U W=2U AS=0.42P AD=0.84P PS=2.42U PD=4.84U
* device instance $86 r0 *1 1043.781,6 cap_mim_1f0_m4m5_noshield
XCTIMING vss__t8 \$24__t8 cap_mim_1f0fF c_width=20u c_length=10u m='(1+d_ctiming)'
* device instance $87 r0 *1 52.03,1 ppolyf_u_1k
X$87 vdd__t0 \$5__t0 vsubs ppolyf_u_1k r_length=100U r_width=2U m='1/(1+d__87)'
* device instance $88 r0 *1 156.87,1 ppolyf_u_1k
X$88 \$5__t2 \$6__t5 vsubs ppolyf_u_1k r_length=100U r_width=2U m='1/(1+d__88)'
* device instance $89 r0 *1 261.71,1 ppolyf_u_1k
X$89 \$6__t6 vss__t24 vsubs ppolyf_u_1k r_length=100U r_width=2U m='1/(1+d__89)'
* device instance $90 r0 *1 354.17,1 ppolyf_u_1k
X$90 \$1__t0 vss__t1 vsubs ppolyf_u_1k r_length=32U r_width=2U m='1/(1+d__90)'
* device instance $91 r0 *1 428.979,1 ppolyf_u_1k
X$91 vdd__t3 \$8__t0 vsubs ppolyf_u_1k r_length=12.03860U r_width=2U m='1/(1+d__91)'
* device instance $92 r0 *1 442.792,1 ppolyf_u_1k
X$92 \$8__t1 \$9__t0 vsubs ppolyf_u_1k r_length=0.52360U r_width=2U m='1/(1+d__92)'
* device instance $93 r0 *1 459.214,1 ppolyf_u_1k
X$93 \$9__t2 \$12__t0 vsubs ppolyf_u_1k r_length=1.04790U r_width=2U m='1/(1+d__93)'
* device instance $94 r0 *1 476.759,1 ppolyf_u_1k
X$94 \$12__t2 \$14__t0 vsubs ppolyf_u_1k r_length=2.09510U r_width=2U m='1/(1+d__94)'
* device instance $95 r0 *1 496.549,1 ppolyf_u_1k
X$95 \$14__t2 \$16__t0 vsubs ppolyf_u_1k r_length=4.19020U r_width=2U m='1/(1+d__95)'
* device instance $96 r0 *1 520.828,1 ppolyf_u_1k
X$96 \$16__t2 \$18__t0 vsubs ppolyf_u_1k r_length=8.38040U r_width=2U m='1/(1+d__96)'
* device instance $97 r0 *1 554.086,1 ppolyf_u_1k
X$97 \$18__t2 \$20__t0 vsubs ppolyf_u_1k r_length=16.76080U r_width=2U m='1/(1+d__97)'
* device instance $98 r0 *1 605.302,1 ppolyf_u_1k
X$98 \$20__t2 \$22__t0 vsubs ppolyf_u_1k r_length=33.52160U r_width=2U m='1/(1+d__98)'
* device instance $99 r0 *1 692.433,1 ppolyf_u_1k
X$99 \$22__t2 \$24__t0 vsubs ppolyf_u_1k r_length=67.04250U r_width=2U m='1/(1+d__99)'
* device instance _1_t0 r0 *1 0,0
R_1_t0 \$1__t0 \$1 21.4421114888
* device instance _1_t1 r0 *1 0,0
R_1_t1 \$1__t1 \$1 7.23398774743
* device instance _1_t2 r0 *1 0,0
R_1_t2 \$1__t2 \$1 1.87743719341
* device instance _1_t3 r0 *1 0,0
R_1_t3 \$1__t3 \$1 3.33065879522
* device instance _1_t4 r0 *1 0,0
R_1_t4 \$1__t4 \$1 0.731795032845
* device instance _1_t5 r0 *1 0,0
R_1_t5 \$1__t5 \$1 4.63166265634
* device instance _1_t6 r0 *1 0,0
R_1_t6 \$1__t6 \$1 5.93279550764
* device instance _1_t7 r0 *1 0,0
R_1_t7 \$1__t7 \$1 2.03003194051
* device instance _1_t8 r0 *1 0,0
R_1_t8 \$1__t8 \$1 0.580319637779
* device instance _1 r0 *1 0,0
C_1 \$1 vsubs 5.580955e-15
* device instance _11_t0 r0 *1 0,0
R_11_t0 \$11__t0 \$11 54.0814695146
* device instance _11_t1 r0 *1 0,0
R_11_t1 \$11__t1 \$11 21.67046858
* device instance _11_t2 r0 *1 0,0
R_11_t2 \$11__t2 \$11 32.4812619054
* device instance _11 r0 *1 0,0
C_11 \$11 vsubs 3.3639302e-14
* device instance _12_t0 r0 *1 0,0
R_12_t0 \$12__t0 \$12 28.103283598
* device instance _12_t1 r0 *1 0,0
R_12_t1 \$12__t1 \$12 26.6261851676
* device instance _12_t2 r0 *1 0,0
R_12_t2 \$12__t2 \$12 23.6065731401
* device instance _12_t3 r0 *1 0,0
R_12_t3 \$12__t3 \$12 21.924420204
* device instance _12_t4 r0 *1 0,0
R_12_t4 \$12__t4 \$12 49.4142776495
* device instance _12_t5 r0 *1 0,0
R_12_t5 \$12__t5 \$12 50.7991602409
* device instance _12 r0 *1 0,0
C_12 \$12 vsubs 4.3241253e-14
* device instance _13_t0 r0 *1 0,0
R_13_t0 \$13__t0 \$13 21.3957213738
* device instance _13_t1 r0 *1 0,0
R_13_t1 \$13__t1 \$13 32.6856279684
* device instance _13_t2 r0 *1 0,0
R_13_t2 \$13__t2 \$13 54.0534506578
* device instance _13 r0 *1 0,0
C_13 \$13 vsubs 3.3801932e-14
* device instance _14_t0 r0 *1 0,0
R_14_t0 \$14__t0 \$14 28.2261493469
* device instance _14_t1 r0 *1 0,0
R_14_t1 \$14__t1 \$14 26.5095919815
* device instance _14_t2 r0 *1 0,0
R_14_t2 \$14__t2 \$14 22.9883344788
* device instance _14_t3 r0 *1 0,0
R_14_t3 \$14__t3 \$14 20.8666525238
* device instance _14_t4 r0 *1 0,0
R_14_t4 \$14__t4 \$14 48.5682308291
* device instance _14_t5 r0 *1 0,0
R_14_t5 \$14__t5 \$14 49.9994408399
* device instance _14 r0 *1 0,0
C_14 \$14 vsubs 4.2062349e-14
* device instance _15_t0 r0 *1 0,0
R_15_t0 \$15__t0 \$15 20.865829743
* device instance _15_t1 r0 *1 0,0
R_15_t1 \$15__t1 \$15 32.5705171419
* device instance _15_t2 r0 *1 0,0
R_15_t2 \$15__t2 \$15 53.4225531151
* device instance _15 r0 *1 0,0
C_15 \$15 vsubs 3.3489652e-14
* device instance _16_t0 r0 *1 0,0
R_16_t0 \$16__t0 \$16 28.8918035252
* device instance _16_t1 r0 *1 0,0
R_16_t1 \$16__t1 \$16 26.6765756732
* device instance _16_t2 r0 *1 0,0
R_16_t2 \$16__t2 \$16 22.1506899977
* device instance _16_t3 r0 *1 0,0
R_16_t3 \$16__t3 \$16 19.1008366137
* device instance _16_t4 r0 *1 0,0
R_16_t4 \$16__t4 \$16 47.6531598174
* device instance _16_t5 r0 *1 0,0
R_16_t5 \$16__t5 \$16 49.1569343728
* device instance _16 r0 *1 0,0
C_16 \$16 vsubs 4.0848171e-14
* device instance _17_t0 r0 *1 0,0
R_17_t0 \$17__t0 \$17 20.1348237599
* device instance _17_t1 r0 *1 0,0
R_17_t1 \$17__t1 \$17 32.3380336264
* device instance _17_t2 r0 *1 0,0
R_17_t2 \$17__t2 \$17 52.4687426137
* device instance _17 r0 *1 0,0
C_17 \$17 vsubs 3.2959174e-14
* device instance _18_t0 r0 *1 0,0
R_18_t0 \$18__t0 \$18 30.7949826394
* device instance _18_t1 r0 *1 0,0
R_18_t1 \$18__t1 \$18 27.491024659
* device instance _18_t2 r0 *1 0,0
R_18_t2 \$18__t2 \$18 20.7782163817
* device instance _18_t3 r0 *1 0,0
R_18_t3 \$18__t3 \$18 15.6694079535
* device instance _18_t4 r0 *1 0,0
R_18_t4 \$18__t4 \$18 46.5479837697
* device instance _18_t5 r0 *1 0,0
R_18_t5 \$18__t5 \$18 48.1799845967
* device instance _18 r0 *1 0,0
C_18 \$18 vsubs 3.9471983e-14
* device instance _19_t0 r0 *1 0,0
R_19_t0 \$19__t0 \$19 18.9169410659
* device instance _19_t1 r0 *1 0,0
R_19_t1 \$19__t1 \$19 31.7403514978
* device instance _19_t2 r0 *1 0,0
R_19_t2 \$19__t2 \$19 50.6559074363
* device instance _19 r0 *1 0,0
C_19 \$19 vsubs 3.1809376e-14
* device instance _20_t0 r0 *1 0,0
R_20_t0 \$20__t0 \$20 35.9416373288
* device instance _20_t1 r0 *1 0,0
R_20_t1 \$20__t1 \$20 29.9640771328
* device instance _20_t2 r0 *1 0,0
R_20_t2 \$20__t2 \$20 17.8840706477
* device instance _20_t3 r0 *1 0,0
R_20_t3 \$20__t3 \$20 7.68326885638
* device instance _20_t4 r0 *1 0,0
R_20_t4 \$20__t4 \$20 44.7792160706
* device instance _20_t5 r0 *1 0,0
R_20_t5 \$20__t5 \$20 46.6897299637
* device instance _20 r0 *1 0,0
C_20 \$20 vsubs 3.7314466e-14
* device instance _21_t0 r0 *1 0,0
R_21_t0 \$21__t0 \$21 16.8013149489
* device instance _21_t1 r0 *1 0,0
R_21_t1 \$21__t1 \$21 30.6515423216
* device instance _21_t2 r0 *1 0,0
R_21_t2 \$21__t2 \$21 47.4522427296
* device instance _21 r0 *1 0,0
C_21 \$21 vsubs 2.9695325e-14
* device instance _22_t0 r0 *1 0,0
R_22_t0 \$22__t0 \$22 45.2971516696
* device instance _22_t1 r0 *1 0,0
R_22_t1 \$22__t1 \$22 32.7745543702
* device instance _22_t2 r0 *1 0,0
R_22_t2 \$22__t2 \$22 7.57591213929
* device instance _22_t3 r0 *1 0,0
R_22_t3 \$22__t3 \$22 15.3166545729
* device instance _22_t4 r0 *1 0,0
R_22_t4 \$22__t4 \$22 33.9906998251
* device instance _22_t5 r0 *1 0,0
R_22_t5 \$22__t5 \$22 36.3366274229
* device instance _22 r0 *1 0,0
C_22 \$22 vsubs 3.3406074e-14
* device instance _23_t0 r0 *1 0,0
R_23_t0 \$23__t0 \$23 12.6710274561
* device instance _23_t1 r0 *1 0,0
R_23_t1 \$23__t1 \$23 29.0120869822
* device instance _23_t2 r0 *1 0,0
R_23_t2 \$23__t2 \$23 41.6829855617
* device instance _23 r0 *1 0,0
C_23 \$23 vsubs 2.5835691e-14
* device instance _24_t0 r0 *1 0,0
R_24_t0 \$24__t0 \$24 77.2014730204
* device instance _24_t1 r0 *1 0,0
R_24_t1 \$24__t1 \$24 56.900762088
* device instance _24_t2 r0 *1 0,0
R_24_t2 \$24__t2 \$24 38.2602347829
* device instance _24_t3 r0 *1 0,0
R_24_t3 \$24__t3 \$24 9.64549641072
* device instance _24_t4 r0 *1 0,0
R_24_t4 \$24__t4 \$24 32.5845813739
* device instance _24_t5 r0 *1 0,0
R_24_t5 \$24__t5 \$24 22.4267404805
* device instance _24_t6 r0 *1 0,0
R_24_t6 \$24__t6 \$24 22.7799316444
* device instance _24_t7 r0 *1 0,0
R_24_t7 \$24__t7 \$24 23.4863196194
* device instance _24_t8 r0 *1 0,0
R_24_t8 \$24__t8 \$24 57.7217358604
* device instance _24_t9 r0 *1 0,0
R_24_t9 \$24__t9 \$24 23.1331247194
* device instance _24 r0 *1 0,0
C_24 \$24 vsubs 5.6274836e-14
* device instance _25_t0 r0 *1 0,0
R_25_t0 \$25__t0 \$25 0.39012827311
* device instance _25_t1 r0 *1 0,0
R_25_t1 \$25__t1 \$25 30.7828375001
* device instance _25_t2 r0 *1 0,0
R_25_t2 \$25__t2 \$25 30.3927342268
* device instance _25 r0 *1 0,0
C_25 \$25 vsubs 1.8487613e-14
* device instance _27_t0 r0 *1 0,0
R_27_t0 \$27__t0 \$27 1.97061995882
* device instance _27_t1 r0 *1 0,0
R_27_t1 \$27__t1 \$27 3.29995142294
* device instance _27_t2 r0 *1 0,0
R_27_t2 \$27__t2 \$27 0.57865961447
* device instance _27_t3 r0 *1 0,0
R_27_t3 \$27__t3 \$27 1.18908145352
* device instance _27_t4 r0 *1 0,0
R_27_t4 \$27__t4 \$27 0.482075848326
* device instance _27_t5 r0 *1 0,0
R_27_t5 \$27__t5 \$27 0.225241014832
* device instance _27_t6 r0 *1 0,0
R_27_t6 \$27__t6 \$27 1.54260128741
* device instance _27_t7 r0 *1 0,0
R_27_t7 \$27__t7 \$27 0.835568170152
* device instance _27_t8 r0 *1 0,0
R_27_t8 \$27__t8 \$27 0.128777221598
* device instance _27_t9 r0 *1 0,0
R_27_t9 \$27__t9 \$27 1.89612400793
* device instance _27 r0 *1 0,0
C_27 \$27 vsubs 4.987296e-15
* device instance _28_t0 r0 *1 0,0
R_28_t0 \$28__t0 \$28 29.99065
* device instance _28_t1 r0 *1 0,0
R_28_t1 \$28__t1 \$28 3.7621587354
* device instance _28_t2 r0 *1 0,0
R_28_t2 \$28__t2 \$28 22.4663325292
* device instance _28_t3 r0 *1 0,0
R_28_t3 \$28__t3 \$28 3.7621587354
* device instance _28 r0 *1 0,0
C_28 \$28 vsubs 4.39074e-15
* device instance _29_t0 r0 *1 0,0
R_29_t0 \$29__t0 \$29 35.5080228147
* device instance _29_t1 r0 *1 0,0
R_29_t1 \$29__t1 \$29 36.5773576788
* device instance _29_t2 r0 *1 0,0
R_29_t2 \$29__t2 \$29 25.3285093732
* device instance _29_t3 r0 *1 0,0
R_29_t3 \$29__t3 \$29 24.2558101333
* device instance _29 r0 *1 0,0
C_29 \$29 vsubs 2.4210731e-14
* device instance _30_t0 r0 *1 0,0
R_30_t0 \$30__t0 \$30 15.4090621861
* device instance _30_t1 r0 *1 0,0
R_30_t1 \$30__t1 \$30 19.2263332126
* device instance _30_t2 r0 *1 0,0
R_30_t2 \$30__t2 \$30 10.7871363747
* device instance _30_t3 r0 *1 0,0
R_30_t3 \$30__t3 \$30 6.905283797
* device instance _30_t4 r0 *1 0,0
R_30_t4 \$30__t4 \$30 6.27245570917
* device instance _30_t5 r0 *1 0,0
R_30_t5 \$30__t5 \$30 5.63965081426
* device instance _30_t6 r0 *1 0,0
R_30_t6 \$30__t6 \$30 5.00687790615
* device instance _30 r0 *1 0,0
C_30 \$30 vsubs 7.840062e-15
* device instance _31_t0 r0 *1 0,0
R_31_t0 \$31__t0 \$31 19.5705023032
* device instance _31_t1 r0 *1 0,0
R_31_t1 \$31__t1 \$31 19.6916475649
* device instance _31_t2 r0 *1 0,0
R_31_t2 \$31__t2 \$31 14.6285375647
* device instance _31_t3 r0 *1 0,0
R_31_t3 \$31__t3 \$31 14.7529125671
* device instance _31 r0 *1 0,0
C_31 \$31 vsubs 7.571285e-15
* device instance _32_t0 r0 *1 0,0
R_32_t0 \$32__t0 \$32 41.1234973822
* device instance _32_t1 r0 *1 0,0
R_32_t1 \$32__t1 \$32 10.2519457621
* device instance _32_t2 r0 *1 0,0
R_32_t2 \$32__t2 \$32 49.4103859886
* device instance _32_t3 r0 *1 0,0
R_32_t3 \$32__t3 \$32 18.5336708671
* device instance _32 r0 *1 0,0
C_32 \$32 vsubs 2.3816832e-14
* device instance _33_t0 r0 *1 0,0
R_33_t0 \$33__t0 \$33 43.5302149115
* device instance _33_t1 r0 *1 0,0
R_33_t1 \$33__t1 \$33 20.2248300404
* device instance _33_t2 r0 *1 0,0
R_33_t2 \$33__t2 \$33 24.9276589229
* device instance _33_t3 r0 *1 0,0
R_33_t3 \$33__t3 \$33 35.965974028
* device instance _33_t4 r0 *1 0,0
R_33_t4 \$33__t4 \$33 2.9473220972
* device instance _33 r0 *1 0,0
C_33 \$33 vsubs 2.6469609e-14
* device instance _34_t0 r0 *1 0,0
R_34_t0 \$34__t0 \$34 14.6042
* device instance _34_t1 r0 *1 0,0
R_34_t1 \$34__t1 \$34 14.6042
* device instance _34 r0 *1 0,0
C_34 \$34 vsubs 1.006904e-14
* device instance _35_t0 r0 *1 0,0
R_35_t0 \$35__t0 \$35 30.5598274076
* device instance _35_t1 r0 *1 0,0
R_35_t1 \$35__t1 \$35 30.5598274076
* device instance _35_t2 r0 *1 0,0
R_35_t2 \$35__t2 \$35 19.0056770779
* device instance _35_t3 r0 *1 0,0
R_35_t3 \$35__t3 \$35 29.8065196088
* device instance _35_t4 r0 *1 0,0
R_35_t4 \$35__t4 \$35 29.6233884543
* device instance _35_t5 r0 *1 0,0
R_35_t5 \$35__t5 \$35 28.52460153
* device instance _35_t6 r0 *1 0,0
R_35_t6 \$35__t6 \$35 39.8221445005
* device instance _35_t7 r0 *1 0,0
R_35_t7 \$35__t7 \$35 29.4402572999
* device instance _35_t8 r0 *1 0,0
R_35_t8 \$35__t8 \$35 29.2571261457
* device instance _35_t9 r0 *1 0,0
R_35_t9 \$35__t9 \$35 29.0739949916
* device instance _35_t10 r0 *1 0,0
R_35_t10 \$35__t10 \$35 28.8908638376
* device instance _35_t11 r0 *1 0,0
R_35_t11 \$35__t11 \$35 28.7077326837
* device instance _35_t12 r0 *1 0,0
R_35_t12 \$35__t12 \$35 38.7233575474
* device instance _35_t13 r0 *1 0,0
R_35_t13 \$35__t13 \$35 38.9064887061
* device instance _35_t14 r0 *1 0,0
R_35_t14 \$35__t14 \$35 39.0896198649
* device instance _35_t15 r0 *1 0,0
R_35_t15 \$35__t15 \$35 39.2727510237
* device instance _35_t16 r0 *1 0,0
R_35_t16 \$35__t16 \$35 39.4558821826
* device instance _35_t17 r0 *1 0,0
R_35_t17 \$35__t17 \$35 39.6390133415
* device instance _35_t18 r0 *1 0,0
R_35_t18 \$35__t18 \$35 38.5402263887
* device instance _35 r0 *1 0,0
C_35 \$35 vsubs 6.0323204e-14
* device instance _4_t0 r0 *1 0,0
R_4_t0 \$4__t0 \$4 0.23358638158
* device instance _4_t1 r0 *1 0,0
R_4_t1 \$4__t1 \$4 0.371168543125
* device instance _4_t2 r0 *1 0,0
R_4_t2 \$4__t2 \$4 2.15175068841
* device instance _4_t3 r0 *1 0,0
R_4_t3 \$4__t3 \$4 1.56527939798
* device instance _4_t4 r0 *1 0,0
R_4_t4 \$4__t4 \$4 1.76073740053
* device instance _4_t5 r0 *1 0,0
R_4_t5 \$4__t5 \$4 1.95623107124
* device instance _4_t6 r0 *1 0,0
R_4_t6 \$4__t6 \$4 0.182987377317
* device instance _4_t7 r0 *1 0,0
R_4_t7 \$4__t7 \$4 0.0758279874152
* device instance _4_t8 r0 *1 0,0
R_4_t8 \$4__t8 \$4 1.78267655117
* device instance _4_t9 r0 *1 0,0
R_4_t9 \$4__t9 \$4 1.48186690123
* device instance _4_t10 r0 *1 0,0
R_4_t10 \$4__t10 \$4 2.38516856115
* device instance _4_t11 r0 *1 0,0
R_4_t11 \$4__t11 \$4 2.08381913885
* device instance _4 r0 *1 0,0
C_4 \$4 vsubs 6.58871e-15
* device instance _42_t0 r0 *1 0,0
R_42_t0 \$42__t0 \$42 24.3126257576
* device instance _42_t1 r0 *1 0,0
R_42_t1 \$42__t1 \$42 7.68146244488
* device instance _42_t2 r0 *1 0,0
R_42_t2 \$42__t2 \$42 20.5394909007
* device instance _42_t3 r0 *1 0,0
R_42_t3 \$42__t3 \$42 11.2640208968
* device instance _42 r0 *1 0,0
C_42 \$42 vsubs 5.799854e-15
* device instance _43_t0 r0 *1 0,0
R_43_t0 \$43__t0 \$43 12.3415947326
* device instance _43_t1 r0 *1 0,0
R_43_t1 \$43__t1 \$43 12.3415947326
* device instance _43_t2 r0 *1 0,0
R_43_t2 \$43__t2 \$43 8.78871585674
* device instance _43_t3 r0 *1 0,0
R_43_t3 \$43__t3 \$43 8.64782376762
* device instance _43_t4 r0 *1 0,0
R_43_t4 \$43__t4 \$43 9.20752622617
* device instance _43_t5 r0 *1 0,0
R_43_t5 \$43__t5 \$43 7.52842230384
* device instance _43_t6 r0 *1 0,0
R_43_t6 \$43__t6 \$43 8.08812238052
* device instance _43 r0 *1 0,0
C_43 \$43 vsubs 6.926501e-15
* device instance _45_t0 r0 *1 0,0
R_45_t0 \$45__t0 \$45 14.41135
* device instance _45_t1 r0 *1 0,0
R_45_t1 \$45__t1 \$45 14.41135
* device instance _45 r0 *1 0,0
C_45 \$45 vsubs 9.932517e-15
* device instance _5_t0 r0 *1 0,0
R_5_t0 \$5__t0 \$5 93.6263714086
* device instance _5_t1 r0 *1 0,0
R_5_t1 \$5__t1 \$5 155.470397136
* device instance _5_t2 r0 *1 0,0
R_5_t2 \$5__t2 \$5 61.8440314559
* device instance _5 r0 *1 0,0
C_5 \$5 vsubs 6.0367141e-14
* device instance _6_t0 r0 *1 0,0
R_6_t0 \$6__t0 \$6 55.5936735772
* device instance _6_t1 r0 *1 0,0
R_6_t1 \$6__t1 \$6 60.0897622997
* device instance _6_t2 r0 *1 0,0
R_6_t2 \$6__t2 \$6 59.9001281454
* device instance _6_t3 r0 *1 0,0
R_6_t3 \$6__t3 \$6 59.7104939919
* device instance _6_t4 r0 *1 0,0
R_6_t4 \$6__t4 \$6 59.5208598393
* device instance _6_t5 r0 *1 0,0
R_6_t5 \$6__t5 \$6 102.618817202
* device instance _6_t6 r0 *1 0,0
R_6_t6 \$6__t6 \$6 81.008764944
* device instance _6 r0 *1 0,0
C_6 \$6 vsubs 7.303483e-14
* device instance _7_t0 r0 *1 0,0
R_7_t0 \$7__t0 \$7 9.92762425093
* device instance _7_t1 r0 *1 0,0
R_7_t1 \$7__t1 \$7 8.55820729427
* device instance _7_t2 r0 *1 0,0
R_7_t2 \$7__t2 \$7 38.5326398093
* device instance _7_t3 r0 *1 0,0
R_7_t3 \$7__t3 \$7 38.6581370364
* device instance _7_t4 r0 *1 0,0
R_7_t4 \$7__t4 \$7 38.9091314945
* device instance _7_t5 r0 *1 0,0
R_7_t5 \$7__t5 \$7 38.7836342649
* device instance _7_t6 r0 *1 0,0
R_7_t6 \$7__t6 \$7 8.01556360133
* device instance _7_t7 r0 *1 0,0
R_7_t7 \$7__t7 \$7 8.55820729427
* device instance _7_t8 r0 *1 0,0
R_7_t8 \$7__t8 \$7 15.1662778206
* device instance _7_t9 r0 *1 0,0
R_7_t9 \$7__t9 \$7 14.9152832129
* device instance _7_t10 r0 *1 0,0
R_7_t10 \$7__t10 \$7 14.6642886131
* device instance _7_t11 r0 *1 0,0
R_7_t11 \$7__t11 \$7 14.5387913164
* device instance _7_t12 r0 *1 0,0
R_7_t12 \$7__t12 \$7 15.417272436
* device instance _7_t13 r0 *1 0,0
R_7_t13 \$7__t13 \$7 15.2917751274
* device instance _7_t14 r0 *1 0,0
R_7_t14 \$7__t14 \$7 15.0407805158
* device instance _7_t15 r0 *1 0,0
R_7_t15 \$7__t15 \$7 14.789785912
* device instance _7 r0 *1 0,0
C_7 \$7 vsubs 5.4776e-14
* device instance _8_t0 r0 *1 0,0
R_8_t0 \$8__t0 \$8 35.3926704527
* device instance _8_t1 r0 *1 0,0
R_8_t1 \$8__t1 \$8 29.9814052311
* device instance _8_t2 r0 *1 0,0
R_8_t2 \$8__t2 \$8 27.8852134863
* device instance _8_t3 r0 *1 0,0
R_8_t3 \$8__t3 \$8 93.0568108299
* device instance _8 r0 *1 0,0
C_8 \$8 vsubs 3.7115868e-14
* device instance _9_t0 r0 *1 0,0
R_9_t0 \$9__t0 \$9 28.3225239327
* device instance _9_t1 r0 *1 0,0
R_9_t1 \$9__t1 \$9 26.9668340377
* device instance _9_t2 r0 *1 0,0
R_9_t2 \$9__t2 \$9 24.2044620705
* device instance _9_t3 r0 *1 0,0
R_9_t3 \$9__t3 \$9 22.7198674066
* device instance _9_t4 r0 *1 0,0
R_9_t4 \$9__t4 \$9 50.3829275422
* device instance _9_t5 r0 *1 0,0
R_9_t5 \$9__t5 \$9 51.7292850104
* device instance _9 r0 *1 0,0
C_9 \$9 vsubs 4.4676943e-14
* device instance clk_t0 r0 *1 0,0
Rclk_t0 clk__t0 clk 52.0894581702
* device instance clk_t1 r0 *1 0,0
Rclk_t1 clk__t1 clk 28.0339506454
* device instance clk_t2 r0 *1 0,0
Rclk_t2 clk__t2 clk 54.7995009588
* device instance clk_t3 r0 *1 0,0
Rclk_t3 clk__t3 clk 11.9860313159
* device instance clk_t4 r0 *1 0,0
Rclk_t4 clk__t4 clk 4.6135333559
* device instance clk_t5 r0 *1 0,0
Rclk_t5 clk__t5 clk 24.2481255539
* device instance clk r0 *1 0,0
Cclk clk vsubs 3.1617714e-14
* device instance t0_t0 r0 *1 0,0
Rt0_t0 t0__t0 t0 47.7308413037
* device instance t0_t1 r0 *1 0,0
Rt0_t1 t0__t1 t0 45.5791995044
* device instance t0_t2 r0 *1 0,0
Rt0_t2 t0__t2 t0 93.2069591919
* device instance t0 r0 *1 0,0
Ct0 t0 vsubs 3.7728127e-14
* device instance t1_t0 r0 *1 0,0
Rt1_t0 t1__t0 t1 47.6598031092
* device instance t1_t1 r0 *1 0,0
Rt1_t1 t1__t1 t1 93.0906636485
* device instance t1_t2 r0 *1 0,0
Rt1_t2 t1__t2 t1 45.4754332423
* device instance t1 r0 *1 0,0
Ct1 t1 vsubs 3.7784624e-14
* device instance t2_t0 r0 *1 0,0
Rt2_t0 t2__t0 t2 47.3154731282
* device instance t2_t1 r0 *1 0,0
Rt2_t1 t2__t1 t2 92.3664519122
* device instance t2_t2 r0 *1 0,0
Rt2_t2 t2__t2 t2 45.0753749596
* device instance t2 r0 *1 0,0
Ct2 t2 vsubs 3.7371504e-14
* device instance t3_t0 r0 *1 0,0
Rt3_t0 t3__t0 t3 46.8238087098
* device instance t3_t1 r0 *1 0,0
Rt3_t1 t3__t1 t3 91.3188877248
* device instance t3_t2 r0 *1 0,0
Rt3_t2 t3__t2 t3 44.5047035654
* device instance t3 r0 *1 0,0
Ct3 t3 vsubs 3.6740185e-14
* device instance t4_t0 r0 *1 0,0
Rt4_t0 t4__t0 t4 45.9274378005
* device instance t4_t1 r0 *1 0,0
Rt4_t1 t4__t1 t4 89.4106649324
* device instance t4_t2 r0 *1 0,0
Rt4_t2 t4__t2 t4 43.4880972671
* device instance t4 r0 *1 0,0
Ct4 t4 vsubs 3.5489546e-14
* device instance t5_t0 r0 *1 0,0
Rt5_t0 t5__t0 t5 44.3869281604
* device instance t5_t1 r0 *1 0,0
Rt5_t1 t5__t1 t5 86.110946572
* device instance t5_t2 r0 *1 0,0
Rt5_t2 t5__t2 t5 41.7274252676
* device instance t5 r0 *1 0,0
Ct5 t5 vsubs 3.3274655e-14
* device instance t6_t0 r0 *1 0,0
Rt6_t0 t6__t0 t6 41.7260170546
* device instance t6_t1 r0 *1 0,0
Rt6_t1 t6__t1 t6 80.245646295
* device instance t6_t2 r0 *1 0,0
Rt6_t2 t6__t2 t6 38.5220366504
* device instance t6 r0 *1 0,0
Ct6 t6 vsubs 2.931418e-14
* device instance t7_t0 r0 *1 0,0
Rt7_t0 t7__t0 t7 37.6099900379
* device instance t7_t1 r0 *1 0,0
Rt7_t1 t7__t1 t7 69.2490505513
* device instance t7_t2 r0 *1 0,0
Rt7_t2 t7__t2 t7 31.6418594108
* device instance t7 r0 *1 0,0
Ct7 t7 vsubs 2.1862613e-14
* device instance vdd_t0 r0 *1 0,0
Rvdd_t0 vdd__t0 vdd 72.0424852935
* device instance vdd_t1 r0 *1 0,0
Rvdd_t1 vdd__t1 vdd 39.9648929864
* device instance vdd_t2 r0 *1 0,0
Rvdd_t2 vdd__t2 vdd 39.9648929864
* device instance vdd_t3 r0 *1 0,0
Rvdd_t3 vdd__t3 vdd 37.343543672
* device instance vdd_t4 r0 *1 0,0
Rvdd_t4 vdd__t4 vdd 7.30187950698
* device instance vdd_t5 r0 *1 0,0
Rvdd_t5 vdd__t5 vdd 6.76903015541
* device instance vdd_t6 r0 *1 0,0
Rvdd_t6 vdd__t6 vdd 6.25927351853
* device instance vdd_t7 r0 *1 0,0
Rvdd_t7 vdd__t7 vdd 5.75351022735
* device instance vdd_t8 r0 *1 0,0
Rvdd_t8 vdd__t8 vdd 5.25302084798
* device instance vdd_t9 r0 *1 0,0
Rvdd_t9 vdd__t9 vdd 4.75383235392
* device instance vdd_t10 r0 *1 0,0
Rvdd_t10 vdd__t10 vdd 4.25507966878
* device instance vdd_t11 r0 *1 0,0
Rvdd_t11 vdd__t11 vdd 3.75693636424
* device instance vdd_t12 r0 *1 0,0
Rvdd_t12 vdd__t12 vdd 3.2471609843
* device instance vdd_t13 r0 *1 0,0
Rvdd_t13 vdd__t13 vdd 3.2471609843
* device instance vdd_t14 r0 *1 0,0
Rvdd_t14 vdd__t14 vdd 9.08356084596
* device instance vdd_t15 r0 *1 0,0
Rvdd_t15 vdd__t15 vdd 9.08356084596
* device instance vdd_t16 r0 *1 0,0
Rvdd_t16 vdd__t16 vdd 9.21427417151
* device instance vdd_t17 r0 *1 0,0
Rvdd_t17 vdd__t17 vdd 9.47570090967
* device instance vdd_t18 r0 *1 0,0
Rvdd_t18 vdd__t18 vdd 9.47570090967
* device instance vdd_t19 r0 *1 0,0
Rvdd_t19 vdd__t19 vdd 10.017971248
* device instance vdd_t20 r0 *1 0,0
Rvdd_t20 vdd__t20 vdd 10.1026581544
* device instance vdd_t21 r0 *1 0,0
Rvdd_t21 vdd__t21 vdd 10.2720320306
* device instance vdd_t22 r0 *1 0,0
Rvdd_t22 vdd__t22 vdd 11.0452615698
* device instance vdd_t23 r0 *1 0,0
Rvdd_t23 vdd__t23 vdd 10.9605744532
* device instance vdd_t24 r0 *1 0,0
Rvdd_t24 vdd__t24 vdd 10.8758873533
* device instance vdd_t25 r0 *1 0,0
Rvdd_t25 vdd__t25 vdd 10.1873450821
* device instance vdd_t26 r0 *1 0,0
Rvdd_t26 vdd__t26 vdd 10.7912002705
* device instance vdd_t27 r0 *1 0,0
Rvdd_t27 vdd__t27 vdd 9.34498752648
* device instance vdd_t28 r0 *1 0,0
Rvdd_t28 vdd__t28 vdd 2.2089190206
* device instance vdd_t29 r0 *1 0,0
Rvdd_t29 vdd__t29 vdd 1.68984820724
* device instance vdd_t30 r0 *1 0,0
Rvdd_t30 vdd__t30 vdd 1.1708701506
* device instance vdd_t31 r0 *1 0,0
Rvdd_t31 vdd__t31 vdd 0.652206315297
* device instance vdd_t32 r0 *1 0,0
Rvdd_t32 vdd__t32 vdd 0.137460786997
* device instance vdd_t33 r0 *1 0,0
Rvdd_t33 vdd__t33 vdd 0.389235250602
* device instance vdd_t34 r0 *1 0,0
Rvdd_t34 vdd__t34 vdd 5.72370626454
* device instance vdd_t35 r0 *1 0,0
Rvdd_t35 vdd__t35 vdd 11.5643633229
* device instance vdd_t36 r0 *1 0,0
Rvdd_t36 vdd__t36 vdd 12.0835359436
* device instance vdd_t37 r0 *1 0,0
Rvdd_t37 vdd__t37 vdd 15.6717234075
* device instance vdd_t38 r0 *1 0,0
Rvdd_t38 vdd__t38 vdd 16.1908972834
* device instance vdd_t39 r0 *1 0,0
Rvdd_t39 vdd__t39 vdd 16.7100712549
* device instance vdd_t40 r0 *1 0,0
Rvdd_t40 vdd__t40 vdd 17.2292453134
* device instance vdd_t41 r0 *1 0,0
Rvdd_t41 vdd__t41 vdd 2.72802964385
* device instance vdd_t42 r0 *1 0,0
Rvdd_t42 vdd__t42 vdd 2.2089190206
* device instance vdd_t43 r0 *1 0,0
Rvdd_t43 vdd__t43 vdd 1.68984820724
* device instance vdd_t44 r0 *1 0,0
Rvdd_t44 vdd__t44 vdd 1.1708701506
* device instance vdd_t45 r0 *1 0,0
Rvdd_t45 vdd__t45 vdd 0.652206315297
* device instance vdd_t46 r0 *1 0,0
Rvdd_t46 vdd__t46 vdd 0.137460786997
* device instance vdd_t47 r0 *1 0,0
Rvdd_t47 vdd__t47 vdd 0.389235250602
* device instance vdd_t48 r0 *1 0,0
Rvdd_t48 vdd__t48 vdd 5.72370626454
* device instance vdd_t49 r0 *1 0,0
Rvdd_t49 vdd__t49 vdd 11.5643633229
* device instance vdd_t50 r0 *1 0,0
Rvdd_t50 vdd__t50 vdd 12.0835359436
* device instance vdd_t51 r0 *1 0,0
Rvdd_t51 vdd__t51 vdd 15.6717234075
* device instance vdd_t52 r0 *1 0,0
Rvdd_t52 vdd__t52 vdd 16.7100712549
* device instance vdd_t53 r0 *1 0,0
Rvdd_t53 vdd__t53 vdd 2.72802964385
* device instance vdd_t54 r0 *1 0,0
Rvdd_t54 vdd__t54 vdd 4.61634766787
* device instance vdd_t55 r0 *1 0,0
Rvdd_t55 vdd__t55 vdd 5.18153150289
* device instance vdd_t56 r0 *1 0,0
Rvdd_t56 vdd__t56 vdd 39.3996916525
* device instance vdd_t57 r0 *1 0,0
Rvdd_t57 vdd__t57 vdd 4.61634766787
* device instance vdd_t58 r0 *1 0,0
Rvdd_t58 vdd__t58 vdd 5.18153150289
* device instance vdd_t59 r0 *1 0,0
Rvdd_t59 vdd__t59 vdd 39.3996916525
* device instance vdd_t60 r0 *1 0,0
Rvdd_t60 vdd__t60 vdd 9.34498752648
* device instance vdd_t61 r0 *1 0,0
Rvdd_t61 vdd__t61 vdd 9.21427417151
* device instance vdd r0 *1 0,0
Cvdd vdd vsubs 2.03568022e-13
* device instance vss_t0 r0 *1 0,0
Rvss_t0 vss__t0 vss 39.5497751162
* device instance vss_t1 r0 *1 0,0
Rvss_t1 vss__t1 vss 36.1332753691
* device instance vss_t2 r0 *1 0,0
Rvss_t2 vss__t2 vss 33.2947833303
* device instance vss_t3 r0 *1 0,0
Rvss_t3 vss__t3 vss 27.0024280272
* device instance vss_t4 r0 *1 0,0
Rvss_t4 vss__t4 vss 12.1779514824
* device instance vss_t5 r0 *1 0,0
Rvss_t5 vss__t5 vss 15.1006615356
* device instance vss_t6 r0 *1 0,0
Rvss_t6 vss__t6 vss 16.1531868826
* device instance vss_t7 r0 *1 0,0
Rvss_t7 vss__t7 vss 21.3021903852
* device instance vss_t8 r0 *1 0,0
Rvss_t8 vss__t8 vss 27.3410813073
* device instance vss_t9 r0 *1 0,0
Rvss_t9 vss__t9 vss 10.6799861254
* device instance vss_t10 r0 *1 0,0
Rvss_t10 vss__t10 vss 9.76511460579
* device instance vss_t11 r0 *1 0,0
Rvss_t11 vss__t11 vss 15.638171005
* device instance vss_t12 r0 *1 0,0
Rvss_t12 vss__t12 vss 23.7727736567
* device instance vss_t13 r0 *1 0,0
Rvss_t13 vss__t13 vss 19.3035413427
* device instance vss_t14 r0 *1 0,0
Rvss_t14 vss__t14 vss 21.8136294007
* device instance vss_t15 r0 *1 0,0
Rvss_t15 vss__t15 vss 25.45644582
* device instance vss_t16 r0 *1 0,0
Rvss_t16 vss__t16 vss 15.6915688776
* device instance vss_t17 r0 *1 0,0
Rvss_t17 vss__t17 vss 9.87585497462
* device instance vss_t18 r0 *1 0,0
Rvss_t18 vss__t18 vss 0.353340778821
* device instance vss_t19 r0 *1 0,0
Rvss_t19 vss__t19 vss 16.6442560268
* device instance vss_t20 r0 *1 0,0
Rvss_t20 vss__t20 vss 22.2715178599
* device instance vss_t21 r0 *1 0,0
Rvss_t21 vss__t21 vss 22.7630066038
* device instance vss_t22 r0 *1 0,0
Rvss_t22 vss__t22 vss 23.2544954297
* device instance vss_t23 r0 *1 0,0
Rvss_t23 vss__t23 vss 21.7800292035
* device instance vss_t24 r0 *1 0,0
Rvss_t24 vss__t24 vss 44.6432327263
* device instance vss_t25 r0 *1 0,0
Rvss_t25 vss__t25 vss 9.89581052977
* device instance vss_t26 r0 *1 0,0
Rvss_t26 vss__t26 vss 10.1572023855
* device instance vss_t27 r0 *1 0,0
Rvss_t27 vss__t27 vss 10.4185942509
* device instance vss_t28 r0 *1 0,0
Rvss_t28 vss__t28 vss 10.0265064564
* device instance vss_t29 r0 *1 0,0
Rvss_t29 vss__t29 vss 10.2878983171
* device instance vss_t30 r0 *1 0,0
Rvss_t30 vss__t30 vss 10.5492901871
* device instance vss r0 *1 0,0
Cvss vss vsubs 1.80554236e-13
* device instance cc__1__35 r0 *1 0,0
Ccc__1__35 \$1 \$35 1.0412e-17
* device instance cc__1__7 r0 *1 0,0
Ccc__1__7 \$1 \$7 1.0412e-17
* device instance cc__11__12 r0 *1 0,0
Ccc__11__12 \$11 \$12 1.0412e-17
* device instance cc__11__13 r0 *1 0,0
Ccc__11__13 \$11 \$13 2.0825e-17
* device instance cc__11__14 r0 *1 0,0
Ccc__11__14 \$11 \$14 1.0412e-17
* device instance cc__11__15 r0 *1 0,0
Ccc__11__15 \$11 \$15 2.0825e-17
* device instance cc__11__16 r0 *1 0,0
Ccc__11__16 \$11 \$16 1.0412e-17
* device instance cc__11__17 r0 *1 0,0
Ccc__11__17 \$11 \$17 2.0825e-17
* device instance cc__11__18 r0 *1 0,0
Ccc__11__18 \$11 \$18 1.0412e-17
* device instance cc__11__19 r0 *1 0,0
Ccc__11__19 \$11 \$19 2.0825e-17
* device instance cc__11__20 r0 *1 0,0
Ccc__11__20 \$11 \$20 1.0412e-17
* device instance cc__11__21 r0 *1 0,0
Ccc__11__21 \$11 \$21 2.0825e-17
* device instance cc__11__22 r0 *1 0,0
Ccc__11__22 \$11 \$22 1.0412e-17
* device instance cc__11__23 r0 *1 0,0
Ccc__11__23 \$11 \$23 2.0825e-17
* device instance cc__11__24 r0 *1 0,0
Ccc__11__24 \$11 \$24 2.0825e-17
* device instance cc__11__25 r0 *1 0,0
Ccc__11__25 \$11 \$25 2.0825e-17
* device instance cc__11__8 r0 *1 0,0
Ccc__11__8 \$11 \$8 1.0412e-17
* device instance cc__11__9 r0 *1 0,0
Ccc__11__9 \$11 \$9 2.0825e-17
* device instance cc__11_t0 r0 *1 0,0
Ccc__11_t0 \$11 t0 1.0412e-17
* device instance cc__11_t1 r0 *1 0,0
Ccc__11_t1 \$11 t1 2.0825e-17
* device instance cc__11_t2 r0 *1 0,0
Ccc__11_t2 \$11 t2 2.0825e-17
* device instance cc__11_t3 r0 *1 0,0
Ccc__11_t3 \$11 t3 2.0825e-17
* device instance cc__11_t4 r0 *1 0,0
Ccc__11_t4 \$11 t4 2.0825e-17
* device instance cc__11_t5 r0 *1 0,0
Ccc__11_t5 \$11 t5 2.0825e-17
* device instance cc__11_t6 r0 *1 0,0
Ccc__11_t6 \$11 t6 2.0825e-17
* device instance cc__11_t7 r0 *1 0,0
Ccc__11_t7 \$11 t7 2.0825e-17
* device instance cc__11_vdd r0 *1 0,0
Ccc__11_vdd \$11 vdd 1.0412e-17
* device instance cc__11_vss r0 *1 0,0
Ccc__11_vss \$11 vss 7.2887e-17
* device instance cc__12__13 r0 *1 0,0
Ccc__12__13 \$12 \$13 2.0825e-17
* device instance cc__12__14 r0 *1 0,0
Ccc__12__14 \$12 \$14 4.1649e-17
* device instance cc__12__15 r0 *1 0,0
Ccc__12__15 \$12 \$15 1.0412e-17
* device instance cc__12__16 r0 *1 0,0
Ccc__12__16 \$12 \$16 4.1649e-17
* device instance cc__12__17 r0 *1 0,0
Ccc__12__17 \$12 \$17 1.0412e-17
* device instance cc__12__18 r0 *1 0,0
Ccc__12__18 \$12 \$18 4.1649e-17
* device instance cc__12__19 r0 *1 0,0
Ccc__12__19 \$12 \$19 1.0412e-17
* device instance cc__12__20 r0 *1 0,0
Ccc__12__20 \$12 \$20 4.1649e-17
* device instance cc__12__21 r0 *1 0,0
Ccc__12__21 \$12 \$21 1.0412e-17
* device instance cc__12__22 r0 *1 0,0
Ccc__12__22 \$12 \$22 4.1649e-17
* device instance cc__12__23 r0 *1 0,0
Ccc__12__23 \$12 \$23 1.0412e-17
* device instance cc__12__24 r0 *1 0,0
Ccc__12__24 \$12 \$24 3.1237e-17
* device instance cc__12__25 r0 *1 0,0
Ccc__12__25 \$12 \$25 1.0412e-17
* device instance cc__12__8 r0 *1 0,0
Ccc__12__8 \$12 \$8 4.1649e-17
* device instance cc__12__9 r0 *1 0,0
Ccc__12__9 \$12 \$9 4.1649e-17
* device instance cc__12_t1 r0 *1 0,0
Ccc__12_t1 \$12 t1 2.0825e-17
* device instance cc__12_t2 r0 *1 0,0
Ccc__12_t2 \$12 t2 2.0825e-17
* device instance cc__12_t3 r0 *1 0,0
Ccc__12_t3 \$12 t3 2.0825e-17
* device instance cc__12_t4 r0 *1 0,0
Ccc__12_t4 \$12 t4 2.0825e-17
* device instance cc__12_t5 r0 *1 0,0
Ccc__12_t5 \$12 t5 2.0825e-17
* device instance cc__12_t6 r0 *1 0,0
Ccc__12_t6 \$12 t6 2.0825e-17
* device instance cc__12_t7 r0 *1 0,0
Ccc__12_t7 \$12 t7 2.0825e-17
* device instance cc__12_vss r0 *1 0,0
Ccc__12_vss \$12 vss 7.2887e-17
* device instance cc__13__14 r0 *1 0,0
Ccc__13__14 \$13 \$14 1.0412e-17
* device instance cc__13__15 r0 *1 0,0
Ccc__13__15 \$13 \$15 2.0825e-17
* device instance cc__13__16 r0 *1 0,0
Ccc__13__16 \$13 \$16 1.0412e-17
* device instance cc__13__17 r0 *1 0,0
Ccc__13__17 \$13 \$17 2.0825e-17
* device instance cc__13__18 r0 *1 0,0
Ccc__13__18 \$13 \$18 1.0412e-17
* device instance cc__13__19 r0 *1 0,0
Ccc__13__19 \$13 \$19 2.0825e-17
* device instance cc__13__20 r0 *1 0,0
Ccc__13__20 \$13 \$20 1.0412e-17
* device instance cc__13__21 r0 *1 0,0
Ccc__13__21 \$13 \$21 2.0825e-17
* device instance cc__13__22 r0 *1 0,0
Ccc__13__22 \$13 \$22 1.0412e-17
* device instance cc__13__23 r0 *1 0,0
Ccc__13__23 \$13 \$23 2.0825e-17
* device instance cc__13__24 r0 *1 0,0
Ccc__13__24 \$13 \$24 2.0825e-17
* device instance cc__13__25 r0 *1 0,0
Ccc__13__25 \$13 \$25 2.0825e-17
* device instance cc__13__8 r0 *1 0,0
Ccc__13__8 \$13 \$8 1.0412e-17
* device instance cc__13__9 r0 *1 0,0
Ccc__13__9 \$13 \$9 1.0412e-17
* device instance cc__13_t0 r0 *1 0,0
Ccc__13_t0 \$13 t0 1.0412e-17
* device instance cc__13_t1 r0 *1 0,0
Ccc__13_t1 \$13 t1 1.0412e-17
* device instance cc__13_t2 r0 *1 0,0
Ccc__13_t2 \$13 t2 2.0825e-17
* device instance cc__13_t3 r0 *1 0,0
Ccc__13_t3 \$13 t3 2.0825e-17
* device instance cc__13_t4 r0 *1 0,0
Ccc__13_t4 \$13 t4 2.0825e-17
* device instance cc__13_t5 r0 *1 0,0
Ccc__13_t5 \$13 t5 2.0825e-17
* device instance cc__13_t6 r0 *1 0,0
Ccc__13_t6 \$13 t6 2.0825e-17
* device instance cc__13_t7 r0 *1 0,0
Ccc__13_t7 \$13 t7 2.0825e-17
* device instance cc__13_vdd r0 *1 0,0
Ccc__13_vdd \$13 vdd 2.0825e-17
* device instance cc__13_vss r0 *1 0,0
Ccc__13_vss \$13 vss 6.2474e-17
* device instance cc__14__15 r0 *1 0,0
Ccc__14__15 \$14 \$15 2.0825e-17
* device instance cc__14__16 r0 *1 0,0
Ccc__14__16 \$14 \$16 4.1649e-17
* device instance cc__14__17 r0 *1 0,0
Ccc__14__17 \$14 \$17 1.0412e-17
* device instance cc__14__18 r0 *1 0,0
Ccc__14__18 \$14 \$18 4.1649e-17
* device instance cc__14__19 r0 *1 0,0
Ccc__14__19 \$14 \$19 1.0412e-17
* device instance cc__14__20 r0 *1 0,0
Ccc__14__20 \$14 \$20 4.1649e-17
* device instance cc__14__21 r0 *1 0,0
Ccc__14__21 \$14 \$21 1.0412e-17
* device instance cc__14__22 r0 *1 0,0
Ccc__14__22 \$14 \$22 4.1649e-17
* device instance cc__14__23 r0 *1 0,0
Ccc__14__23 \$14 \$23 1.0412e-17
* device instance cc__14__24 r0 *1 0,0
Ccc__14__24 \$14 \$24 3.1237e-17
* device instance cc__14__25 r0 *1 0,0
Ccc__14__25 \$14 \$25 1.0412e-17
* device instance cc__14__8 r0 *1 0,0
Ccc__14__8 \$14 \$8 4.1649e-17
* device instance cc__14__9 r0 *1 0,0
Ccc__14__9 \$14 \$9 4.1649e-17
* device instance cc__14_t2 r0 *1 0,0
Ccc__14_t2 \$14 t2 2.0825e-17
* device instance cc__14_t3 r0 *1 0,0
Ccc__14_t3 \$14 t3 2.0825e-17
* device instance cc__14_t4 r0 *1 0,0
Ccc__14_t4 \$14 t4 2.0825e-17
* device instance cc__14_t5 r0 *1 0,0
Ccc__14_t5 \$14 t5 2.0825e-17
* device instance cc__14_t6 r0 *1 0,0
Ccc__14_t6 \$14 t6 2.0825e-17
* device instance cc__14_t7 r0 *1 0,0
Ccc__14_t7 \$14 t7 2.0825e-17
* device instance cc__14_vss r0 *1 0,0
Ccc__14_vss \$14 vss 6.2474e-17
* device instance cc__15__16 r0 *1 0,0
Ccc__15__16 \$15 \$16 1.0412e-17
* device instance cc__15__17 r0 *1 0,0
Ccc__15__17 \$15 \$17 2.0825e-17
* device instance cc__15__18 r0 *1 0,0
Ccc__15__18 \$15 \$18 1.0412e-17
* device instance cc__15__19 r0 *1 0,0
Ccc__15__19 \$15 \$19 2.0825e-17
* device instance cc__15__20 r0 *1 0,0
Ccc__15__20 \$15 \$20 1.0412e-17
* device instance cc__15__21 r0 *1 0,0
Ccc__15__21 \$15 \$21 2.0825e-17
* device instance cc__15__22 r0 *1 0,0
Ccc__15__22 \$15 \$22 1.0412e-17
* device instance cc__15__23 r0 *1 0,0
Ccc__15__23 \$15 \$23 2.0825e-17
* device instance cc__15__24 r0 *1 0,0
Ccc__15__24 \$15 \$24 2.0825e-17
* device instance cc__15__25 r0 *1 0,0
Ccc__15__25 \$15 \$25 2.0825e-17
* device instance cc__15__8 r0 *1 0,0
Ccc__15__8 \$15 \$8 1.0412e-17
* device instance cc__15__9 r0 *1 0,0
Ccc__15__9 \$15 \$9 1.0412e-17
* device instance cc__15_t0 r0 *1 0,0
Ccc__15_t0 \$15 t0 1.0412e-17
* device instance cc__15_t1 r0 *1 0,0
Ccc__15_t1 \$15 t1 1.0412e-17
* device instance cc__15_t2 r0 *1 0,0
Ccc__15_t2 \$15 t2 1.0412e-17
* device instance cc__15_t3 r0 *1 0,0
Ccc__15_t3 \$15 t3 2.0825e-17
* device instance cc__15_t4 r0 *1 0,0
Ccc__15_t4 \$15 t4 2.0825e-17
* device instance cc__15_t5 r0 *1 0,0
Ccc__15_t5 \$15 t5 2.0825e-17
* device instance cc__15_t6 r0 *1 0,0
Ccc__15_t6 \$15 t6 2.0825e-17
* device instance cc__15_t7 r0 *1 0,0
Ccc__15_t7 \$15 t7 2.0825e-17
* device instance cc__15_vdd r0 *1 0,0
Ccc__15_vdd \$15 vdd 3.1237e-17
* device instance cc__15_vss r0 *1 0,0
Ccc__15_vss \$15 vss 5.2062e-17
* device instance cc__16__17 r0 *1 0,0
Ccc__16__17 \$16 \$17 2.0825e-17
* device instance cc__16__18 r0 *1 0,0
Ccc__16__18 \$16 \$18 4.1649e-17
* device instance cc__16__19 r0 *1 0,0
Ccc__16__19 \$16 \$19 1.0412e-17
* device instance cc__16__20 r0 *1 0,0
Ccc__16__20 \$16 \$20 4.1649e-17
* device instance cc__16__21 r0 *1 0,0
Ccc__16__21 \$16 \$21 1.0412e-17
* device instance cc__16__22 r0 *1 0,0
Ccc__16__22 \$16 \$22 4.1649e-17
* device instance cc__16__23 r0 *1 0,0
Ccc__16__23 \$16 \$23 1.0412e-17
* device instance cc__16__24 r0 *1 0,0
Ccc__16__24 \$16 \$24 3.1237e-17
* device instance cc__16__25 r0 *1 0,0
Ccc__16__25 \$16 \$25 1.0412e-17
* device instance cc__16__8 r0 *1 0,0
Ccc__16__8 \$16 \$8 4.1649e-17
* device instance cc__16__9 r0 *1 0,0
Ccc__16__9 \$16 \$9 4.1649e-17
* device instance cc__16_t3 r0 *1 0,0
Ccc__16_t3 \$16 t3 2.0825e-17
* device instance cc__16_t4 r0 *1 0,0
Ccc__16_t4 \$16 t4 2.0825e-17
* device instance cc__16_t5 r0 *1 0,0
Ccc__16_t5 \$16 t5 2.0825e-17
* device instance cc__16_t6 r0 *1 0,0
Ccc__16_t6 \$16 t6 2.0825e-17
* device instance cc__16_t7 r0 *1 0,0
Ccc__16_t7 \$16 t7 2.0825e-17
* device instance cc__16_vss r0 *1 0,0
Ccc__16_vss \$16 vss 5.2062e-17
* device instance cc__17__18 r0 *1 0,0
Ccc__17__18 \$17 \$18 1.0412e-17
* device instance cc__17__19 r0 *1 0,0
Ccc__17__19 \$17 \$19 2.0825e-17
* device instance cc__17__20 r0 *1 0,0
Ccc__17__20 \$17 \$20 1.0412e-17
* device instance cc__17__21 r0 *1 0,0
Ccc__17__21 \$17 \$21 2.0825e-17
* device instance cc__17__22 r0 *1 0,0
Ccc__17__22 \$17 \$22 1.0412e-17
* device instance cc__17__23 r0 *1 0,0
Ccc__17__23 \$17 \$23 2.0825e-17
* device instance cc__17__24 r0 *1 0,0
Ccc__17__24 \$17 \$24 2.0825e-17
* device instance cc__17__25 r0 *1 0,0
Ccc__17__25 \$17 \$25 2.0825e-17
* device instance cc__17__8 r0 *1 0,0
Ccc__17__8 \$17 \$8 1.0412e-17
* device instance cc__17__9 r0 *1 0,0
Ccc__17__9 \$17 \$9 1.0412e-17
* device instance cc__17_t0 r0 *1 0,0
Ccc__17_t0 \$17 t0 1.0412e-17
* device instance cc__17_t1 r0 *1 0,0
Ccc__17_t1 \$17 t1 1.0412e-17
* device instance cc__17_t2 r0 *1 0,0
Ccc__17_t2 \$17 t2 1.0412e-17
* device instance cc__17_t3 r0 *1 0,0
Ccc__17_t3 \$17 t3 1.0412e-17
* device instance cc__17_t4 r0 *1 0,0
Ccc__17_t4 \$17 t4 2.0825e-17
* device instance cc__17_t5 r0 *1 0,0
Ccc__17_t5 \$17 t5 2.0825e-17
* device instance cc__17_t6 r0 *1 0,0
Ccc__17_t6 \$17 t6 2.0825e-17
* device instance cc__17_t7 r0 *1 0,0
Ccc__17_t7 \$17 t7 2.0825e-17
* device instance cc__17_vdd r0 *1 0,0
Ccc__17_vdd \$17 vdd 4.1649e-17
* device instance cc__17_vss r0 *1 0,0
Ccc__17_vss \$17 vss 4.1649e-17
* device instance cc__18__19 r0 *1 0,0
Ccc__18__19 \$18 \$19 2.0825e-17
* device instance cc__18__20 r0 *1 0,0
Ccc__18__20 \$18 \$20 4.1649e-17
* device instance cc__18__21 r0 *1 0,0
Ccc__18__21 \$18 \$21 1.0412e-17
* device instance cc__18__22 r0 *1 0,0
Ccc__18__22 \$18 \$22 4.1649e-17
* device instance cc__18__23 r0 *1 0,0
Ccc__18__23 \$18 \$23 1.0412e-17
* device instance cc__18__24 r0 *1 0,0
Ccc__18__24 \$18 \$24 3.1237e-17
* device instance cc__18__25 r0 *1 0,0
Ccc__18__25 \$18 \$25 1.0412e-17
* device instance cc__18__8 r0 *1 0,0
Ccc__18__8 \$18 \$8 4.1649e-17
* device instance cc__18__9 r0 *1 0,0
Ccc__18__9 \$18 \$9 4.1649e-17
* device instance cc__18_t4 r0 *1 0,0
Ccc__18_t4 \$18 t4 2.0825e-17
* device instance cc__18_t5 r0 *1 0,0
Ccc__18_t5 \$18 t5 2.0825e-17
* device instance cc__18_t6 r0 *1 0,0
Ccc__18_t6 \$18 t6 2.0825e-17
* device instance cc__18_t7 r0 *1 0,0
Ccc__18_t7 \$18 t7 2.0825e-17
* device instance cc__18_vss r0 *1 0,0
Ccc__18_vss \$18 vss 4.1649e-17
* device instance cc__19__20 r0 *1 0,0
Ccc__19__20 \$19 \$20 1.0412e-17
* device instance cc__19__21 r0 *1 0,0
Ccc__19__21 \$19 \$21 2.0825e-17
* device instance cc__19__22 r0 *1 0,0
Ccc__19__22 \$19 \$22 1.0412e-17
* device instance cc__19__23 r0 *1 0,0
Ccc__19__23 \$19 \$23 2.0825e-17
* device instance cc__19__24 r0 *1 0,0
Ccc__19__24 \$19 \$24 2.0825e-17
* device instance cc__19__25 r0 *1 0,0
Ccc__19__25 \$19 \$25 2.0825e-17
* device instance cc__19__8 r0 *1 0,0
Ccc__19__8 \$19 \$8 1.0412e-17
* device instance cc__19__9 r0 *1 0,0
Ccc__19__9 \$19 \$9 1.0412e-17
* device instance cc__19_t0 r0 *1 0,0
Ccc__19_t0 \$19 t0 1.0412e-17
* device instance cc__19_t1 r0 *1 0,0
Ccc__19_t1 \$19 t1 1.0412e-17
* device instance cc__19_t2 r0 *1 0,0
Ccc__19_t2 \$19 t2 1.0412e-17
* device instance cc__19_t3 r0 *1 0,0
Ccc__19_t3 \$19 t3 1.0412e-17
* device instance cc__19_t4 r0 *1 0,0
Ccc__19_t4 \$19 t4 1.0412e-17
* device instance cc__19_t5 r0 *1 0,0
Ccc__19_t5 \$19 t5 2.0825e-17
* device instance cc__19_t6 r0 *1 0,0
Ccc__19_t6 \$19 t6 2.0825e-17
* device instance cc__19_t7 r0 *1 0,0
Ccc__19_t7 \$19 t7 2.0825e-17
* device instance cc__19_vdd r0 *1 0,0
Ccc__19_vdd \$19 vdd 5.2062e-17
* device instance cc__19_vss r0 *1 0,0
Ccc__19_vss \$19 vss 3.1237e-17
* device instance cc__20__21 r0 *1 0,0
Ccc__20__21 \$20 \$21 2.0825e-17
* device instance cc__20__22 r0 *1 0,0
Ccc__20__22 \$20 \$22 4.1649e-17
* device instance cc__20__23 r0 *1 0,0
Ccc__20__23 \$20 \$23 1.0412e-17
* device instance cc__20__24 r0 *1 0,0
Ccc__20__24 \$20 \$24 3.1237e-17
* device instance cc__20__25 r0 *1 0,0
Ccc__20__25 \$20 \$25 1.0412e-17
* device instance cc__20__8 r0 *1 0,0
Ccc__20__8 \$20 \$8 4.1649e-17
* device instance cc__20__9 r0 *1 0,0
Ccc__20__9 \$20 \$9 4.1649e-17
* device instance cc__20_t5 r0 *1 0,0
Ccc__20_t5 \$20 t5 2.0825e-17
* device instance cc__20_t6 r0 *1 0,0
Ccc__20_t6 \$20 t6 2.0825e-17
* device instance cc__20_t7 r0 *1 0,0
Ccc__20_t7 \$20 t7 2.0825e-17
* device instance cc__20_vss r0 *1 0,0
Ccc__20_vss \$20 vss 3.1237e-17
* device instance cc__21__22 r0 *1 0,0
Ccc__21__22 \$21 \$22 1.0412e-17
* device instance cc__21__23 r0 *1 0,0
Ccc__21__23 \$21 \$23 2.0825e-17
* device instance cc__21__24 r0 *1 0,0
Ccc__21__24 \$21 \$24 2.0825e-17
* device instance cc__21__25 r0 *1 0,0
Ccc__21__25 \$21 \$25 2.0825e-17
* device instance cc__21__8 r0 *1 0,0
Ccc__21__8 \$21 \$8 1.0412e-17
* device instance cc__21__9 r0 *1 0,0
Ccc__21__9 \$21 \$9 1.0412e-17
* device instance cc__21_t0 r0 *1 0,0
Ccc__21_t0 \$21 t0 1.0412e-17
* device instance cc__21_t1 r0 *1 0,0
Ccc__21_t1 \$21 t1 1.0412e-17
* device instance cc__21_t2 r0 *1 0,0
Ccc__21_t2 \$21 t2 1.0412e-17
* device instance cc__21_t3 r0 *1 0,0
Ccc__21_t3 \$21 t3 1.0412e-17
* device instance cc__21_t4 r0 *1 0,0
Ccc__21_t4 \$21 t4 1.0412e-17
* device instance cc__21_t5 r0 *1 0,0
Ccc__21_t5 \$21 t5 1.0412e-17
* device instance cc__21_t6 r0 *1 0,0
Ccc__21_t6 \$21 t6 2.0825e-17
* device instance cc__21_t7 r0 *1 0,0
Ccc__21_t7 \$21 t7 2.0825e-17
* device instance cc__21_vdd r0 *1 0,0
Ccc__21_vdd \$21 vdd 6.2474e-17
* device instance cc__21_vss r0 *1 0,0
Ccc__21_vss \$21 vss 2.0825e-17
* device instance cc__22__23 r0 *1 0,0
Ccc__22__23 \$22 \$23 2.0825e-17
* device instance cc__22__24 r0 *1 0,0
Ccc__22__24 \$22 \$24 4.1649e-17
* device instance cc__22__25 r0 *1 0,0
Ccc__22__25 \$22 \$25 1.0412e-17
* device instance cc__22__8 r0 *1 0,0
Ccc__22__8 \$22 \$8 4.1649e-17
* device instance cc__22__9 r0 *1 0,0
Ccc__22__9 \$22 \$9 4.1649e-17
* device instance cc__22_t6 r0 *1 0,0
Ccc__22_t6 \$22 t6 2.0825e-17
* device instance cc__22_t7 r0 *1 0,0
Ccc__22_t7 \$22 t7 2.0825e-17
* device instance cc__22_vss r0 *1 0,0
Ccc__22_vss \$22 vss 2.0825e-17
* device instance cc__23__24 r0 *1 0,0
Ccc__23__24 \$23 \$24 2.0825e-17
* device instance cc__23__25 r0 *1 0,0
Ccc__23__25 \$23 \$25 2.0825e-17
* device instance cc__23__8 r0 *1 0,0
Ccc__23__8 \$23 \$8 1.0412e-17
* device instance cc__23__9 r0 *1 0,0
Ccc__23__9 \$23 \$9 1.0412e-17
* device instance cc__23_t0 r0 *1 0,0
Ccc__23_t0 \$23 t0 1.0412e-17
* device instance cc__23_t1 r0 *1 0,0
Ccc__23_t1 \$23 t1 1.0412e-17
* device instance cc__23_t2 r0 *1 0,0
Ccc__23_t2 \$23 t2 1.0412e-17
* device instance cc__23_t3 r0 *1 0,0
Ccc__23_t3 \$23 t3 1.0412e-17
* device instance cc__23_t4 r0 *1 0,0
Ccc__23_t4 \$23 t4 1.0412e-17
* device instance cc__23_t5 r0 *1 0,0
Ccc__23_t5 \$23 t5 1.0412e-17
* device instance cc__23_t6 r0 *1 0,0
Ccc__23_t6 \$23 t6 1.0412e-17
* device instance cc__23_t7 r0 *1 0,0
Ccc__23_t7 \$23 t7 2.0825e-17
* device instance cc__23_vdd r0 *1 0,0
Ccc__23_vdd \$23 vdd 7.2887e-17
* device instance cc__23_vss r0 *1 0,0
Ccc__23_vss \$23 vss 1.0412e-17
* device instance cc__24__25 r0 *1 0,0
Ccc__24__25 \$24 \$25 2.0825e-17
* device instance cc__24__27 r0 *1 0,0
Ccc__24__27 \$24 \$27 1.0412e-17
* device instance cc__24__29 r0 *1 0,0
Ccc__24__29 \$24 \$29 3.1237e-17
* device instance cc__24__30 r0 *1 0,0
Ccc__24__30 \$24 \$30 1.0412e-17
* device instance cc__24__31 r0 *1 0,0
Ccc__24__31 \$24 \$31 1.0412e-17
* device instance cc__24__32 r0 *1 0,0
Ccc__24__32 \$24 \$32 4.1649e-17
* device instance cc__24__33 r0 *1 0,0
Ccc__24__33 \$24 \$33 5.2062e-17
* device instance cc__24__34 r0 *1 0,0
Ccc__24__34 \$24 \$34 2.0825e-17
* device instance cc__24__35 r0 *1 0,0
Ccc__24__35 \$24 \$35 1.0412e-17
* device instance cc__24__45 r0 *1 0,0
Ccc__24__45 \$24 \$45 2.0825e-17
* device instance cc__24__5 r0 *1 0,0
Ccc__24__5 \$24 \$5 2.0825e-17
* device instance cc__24__6 r0 *1 0,0
Ccc__24__6 \$24 \$6 2.0825e-17
* device instance cc__24__7 r0 *1 0,0
Ccc__24__7 \$24 \$7 2.0825e-17
* device instance cc__24__8 r0 *1 0,0
Ccc__24__8 \$24 \$8 2.0825e-17
* device instance cc__24__9 r0 *1 0,0
Ccc__24__9 \$24 \$9 3.1237e-17
* device instance cc__24_clk r0 *1 0,0
Ccc__24_clk \$24 clk 6.2474e-17
* device instance cc__24_t0 r0 *1 0,0
Ccc__24_t0 \$24 t0 1.0412e-17
* device instance cc__24_t1 r0 *1 0,0
Ccc__24_t1 \$24 t1 1.0412e-17
* device instance cc__24_t2 r0 *1 0,0
Ccc__24_t2 \$24 t2 1.0412e-17
* device instance cc__24_t3 r0 *1 0,0
Ccc__24_t3 \$24 t3 1.0412e-17
* device instance cc__24_t4 r0 *1 0,0
Ccc__24_t4 \$24 t4 1.0412e-17
* device instance cc__24_t5 r0 *1 0,0
Ccc__24_t5 \$24 t5 1.0412e-17
* device instance cc__24_t6 r0 *1 0,0
Ccc__24_t6 \$24 t6 1.0412e-17
* device instance cc__24_t7 r0 *1 0,0
Ccc__24_t7 \$24 t7 3.1237e-17
* device instance cc__24_vdd r0 *1 0,0
Ccc__24_vdd \$24 vdd 7.2887e-17
* device instance cc__24_vss r0 *1 0,0
Ccc__24_vss \$24 vss 2.99808e-16
* device instance cc__25__8 r0 *1 0,0
Ccc__25__8 \$25 \$8 1.0412e-17
* device instance cc__25__9 r0 *1 0,0
Ccc__25__9 \$25 \$9 1.0412e-17
* device instance cc__25_t0 r0 *1 0,0
Ccc__25_t0 \$25 t0 1.0412e-17
* device instance cc__25_t1 r0 *1 0,0
Ccc__25_t1 \$25 t1 1.0412e-17
* device instance cc__25_t2 r0 *1 0,0
Ccc__25_t2 \$25 t2 1.0412e-17
* device instance cc__25_t3 r0 *1 0,0
Ccc__25_t3 \$25 t3 1.0412e-17
* device instance cc__25_t4 r0 *1 0,0
Ccc__25_t4 \$25 t4 1.0412e-17
* device instance cc__25_t5 r0 *1 0,0
Ccc__25_t5 \$25 t5 1.0412e-17
* device instance cc__25_t6 r0 *1 0,0
Ccc__25_t6 \$25 t6 1.0412e-17
* device instance cc__25_t7 r0 *1 0,0
Ccc__25_t7 \$25 t7 1.0412e-17
* device instance cc__25_vdd r0 *1 0,0
Ccc__25_vdd \$25 vdd 8.3299e-17
* device instance cc__27__42 r0 *1 0,0
Ccc__27__42 \$27 \$42 1.0412e-17
* device instance cc__28__29 r0 *1 0,0
Ccc__28__29 \$28 \$29 1.0412e-17
* device instance cc__28__42 r0 *1 0,0
Ccc__28__42 \$28 \$42 1.0412e-17
* device instance cc__28_vdd r0 *1 0,0
Ccc__28_vdd \$28 vdd 2.0825e-17
* device instance cc__28_vss r0 *1 0,0
Ccc__28_vss \$28 vss 1.0412e-17
* device instance cc__29__32 r0 *1 0,0
Ccc__29__32 \$29 \$32 2.0825e-17
* device instance cc__29__33 r0 *1 0,0
Ccc__29__33 \$29 \$33 3.1237e-17
* device instance cc__29__42 r0 *1 0,0
Ccc__29__42 \$29 \$42 1.0412e-17
* device instance cc__29__6 r0 *1 0,0
Ccc__29__6 \$29 \$6 1.0412e-17
* device instance cc__29__7 r0 *1 0,0
Ccc__29__7 \$29 \$7 1.0412e-17
* device instance cc__29_clk r0 *1 0,0
Ccc__29_clk \$29 clk 4.1649e-17
* device instance cc__29_vdd r0 *1 0,0
Ccc__29_vdd \$29 vdd 6.2474e-17
* device instance cc__29_vss r0 *1 0,0
Ccc__29_vss \$29 vss 6.2474e-17
* device instance cc__30__31 r0 *1 0,0
Ccc__30__31 \$30 \$31 2.0825e-17
* device instance cc__30__32 r0 *1 0,0
Ccc__30__32 \$30 \$32 1.0412e-17
* device instance cc__30__43 r0 *1 0,0
Ccc__30__43 \$30 \$43 2.0825e-17
* device instance cc__30__6 r0 *1 0,0
Ccc__30__6 \$30 \$6 1.0412e-17
* device instance cc__30__7 r0 *1 0,0
Ccc__30__7 \$30 \$7 1.0412e-17
* device instance cc__30_vdd r0 *1 0,0
Ccc__30_vdd \$30 vdd 2.0825e-17
* device instance cc__30_vss r0 *1 0,0
Ccc__30_vss \$30 vss 2.0825e-17
* device instance cc__31__32 r0 *1 0,0
Ccc__31__32 \$31 \$32 1.0412e-17
* device instance cc__31__43 r0 *1 0,0
Ccc__31__43 \$31 \$43 2.0825e-17
* device instance cc__31__6 r0 *1 0,0
Ccc__31__6 \$31 \$6 1.0412e-17
* device instance cc__31__7 r0 *1 0,0
Ccc__31__7 \$31 \$7 1.0412e-17
* device instance cc__31_vdd r0 *1 0,0
Ccc__31_vdd \$31 vdd 3.1237e-17
* device instance cc__31_vss r0 *1 0,0
Ccc__31_vss \$31 vss 1.0412e-17
* device instance cc__32__33 r0 *1 0,0
Ccc__32__33 \$32 \$33 4.1649e-17
* device instance cc__32__43 r0 *1 0,0
Ccc__32__43 \$32 \$43 1.0412e-17
* device instance cc__32__45 r0 *1 0,0
Ccc__32__45 \$32 \$45 2.0825e-17
* device instance cc__32__6 r0 *1 0,0
Ccc__32__6 \$32 \$6 2.0825e-17
* device instance cc__32__7 r0 *1 0,0
Ccc__32__7 \$32 \$7 2.0825e-17
* device instance cc__32_clk r0 *1 0,0
Ccc__32_clk \$32 clk 5.2062e-17
* device instance cc__32_vdd r0 *1 0,0
Ccc__32_vdd \$32 vdd 6.2474e-17
* device instance cc__32_vss r0 *1 0,0
Ccc__32_vss \$32 vss 5.2062e-17
* device instance cc__33_clk r0 *1 0,0
Ccc__33_clk \$33 clk 4.1649e-17
* device instance cc__33_vdd r0 *1 0,0
Ccc__33_vdd \$33 vdd 2.0825e-17
* device instance cc__33_vss r0 *1 0,0
Ccc__33_vss \$33 vss 3.1237e-17
* device instance cc__35__5 r0 *1 0,0
Ccc__35__5 \$35 \$5 2.0825e-17
* device instance cc__35__6 r0 *1 0,0
Ccc__35__6 \$35 \$6 4.1649e-17
* device instance cc__35__7 r0 *1 0,0
Ccc__35__7 \$35 \$7 2.0825e-17
* device instance cc__35_t0 r0 *1 0,0
Ccc__35_t0 \$35 t0 1.0412e-17
* device instance cc__35_t1 r0 *1 0,0
Ccc__35_t1 \$35 t1 1.0412e-17
* device instance cc__35_t2 r0 *1 0,0
Ccc__35_t2 \$35 t2 1.0412e-17
* device instance cc__35_t3 r0 *1 0,0
Ccc__35_t3 \$35 t3 1.0412e-17
* device instance cc__35_t4 r0 *1 0,0
Ccc__35_t4 \$35 t4 1.0412e-17
* device instance cc__35_t5 r0 *1 0,0
Ccc__35_t5 \$35 t5 1.0412e-17
* device instance cc__35_t6 r0 *1 0,0
Ccc__35_t6 \$35 t6 1.0412e-17
* device instance cc__35_t7 r0 *1 0,0
Ccc__35_t7 \$35 t7 1.0412e-17
* device instance cc__35_vdd r0 *1 0,0
Ccc__35_vdd \$35 vdd 5.2062e-17
* device instance cc__35_vss r0 *1 0,0
Ccc__35_vss \$35 vss 6.2474e-17
* device instance cc__4__43 r0 *1 0,0
Ccc__4__43 \$4 \$43 1.0412e-17
* device instance cc__4__6 r0 *1 0,0
Ccc__4__6 \$4 \$6 1.0412e-17
* device instance cc__42__5 r0 *1 0,0
Ccc__42__5 \$42 \$5 1.0412e-17
* device instance cc__42_vdd r0 *1 0,0
Ccc__42_vdd \$42 vdd 3.1237e-17
* device instance cc__42_vss r0 *1 0,0
Ccc__42_vss \$42 vss 1.0412e-17
* device instance cc__43__6 r0 *1 0,0
Ccc__43__6 \$43 \$6 1.0412e-17
* device instance cc__43__7 r0 *1 0,0
Ccc__43__7 \$43 \$7 1.0412e-17
* device instance cc__43_vdd r0 *1 0,0
Ccc__43_vdd \$43 vdd 1.0412e-17
* device instance cc__43_vss r0 *1 0,0
Ccc__43_vss \$43 vss 3.1237e-17
* device instance cc__5__6 r0 *1 0,0
Ccc__5__6 \$5 \$6 1.0412e-17
* device instance cc__5__7 r0 *1 0,0
Ccc__5__7 \$5 \$7 1.0412e-17
* device instance cc__5_t0 r0 *1 0,0
Ccc__5_t0 \$5 t0 1.0412e-17
* device instance cc__5_t1 r0 *1 0,0
Ccc__5_t1 \$5 t1 1.0412e-17
* device instance cc__5_t2 r0 *1 0,0
Ccc__5_t2 \$5 t2 1.0412e-17
* device instance cc__5_t3 r0 *1 0,0
Ccc__5_t3 \$5 t3 1.0412e-17
* device instance cc__5_t4 r0 *1 0,0
Ccc__5_t4 \$5 t4 1.0412e-17
* device instance cc__5_t5 r0 *1 0,0
Ccc__5_t5 \$5 t5 1.0412e-17
* device instance cc__5_t6 r0 *1 0,0
Ccc__5_t6 \$5 t6 1.0412e-17
* device instance cc__5_t7 r0 *1 0,0
Ccc__5_t7 \$5 t7 1.0412e-17
* device instance cc__5_vdd r0 *1 0,0
Ccc__5_vdd \$5 vdd 3.1237e-17
* device instance cc__5_vss r0 *1 0,0
Ccc__5_vss \$5 vss 4.1649e-17
* device instance cc__6__7 r0 *1 0,0
Ccc__6__7 \$6 \$7 3.1237e-17
* device instance cc__6_t0 r0 *1 0,0
Ccc__6_t0 \$6 t0 1.0412e-17
* device instance cc__6_t1 r0 *1 0,0
Ccc__6_t1 \$6 t1 1.0412e-17
* device instance cc__6_t2 r0 *1 0,0
Ccc__6_t2 \$6 t2 1.0412e-17
* device instance cc__6_t3 r0 *1 0,0
Ccc__6_t3 \$6 t3 1.0412e-17
* device instance cc__6_t4 r0 *1 0,0
Ccc__6_t4 \$6 t4 1.0412e-17
* device instance cc__6_t5 r0 *1 0,0
Ccc__6_t5 \$6 t5 1.0412e-17
* device instance cc__6_t6 r0 *1 0,0
Ccc__6_t6 \$6 t6 1.0412e-17
* device instance cc__6_t7 r0 *1 0,0
Ccc__6_t7 \$6 t7 1.0412e-17
* device instance cc__6_vdd r0 *1 0,0
Ccc__6_vdd \$6 vdd 6.2474e-17
* device instance cc__6_vss r0 *1 0,0
Ccc__6_vss \$6 vss 8.3299e-17
* device instance cc__7_t0 r0 *1 0,0
Ccc__7_t0 \$7 t0 1.0412e-17
* device instance cc__7_t1 r0 *1 0,0
Ccc__7_t1 \$7 t1 1.0412e-17
* device instance cc__7_t2 r0 *1 0,0
Ccc__7_t2 \$7 t2 1.0412e-17
* device instance cc__7_t3 r0 *1 0,0
Ccc__7_t3 \$7 t3 1.0412e-17
* device instance cc__7_t4 r0 *1 0,0
Ccc__7_t4 \$7 t4 1.0412e-17
* device instance cc__7_t5 r0 *1 0,0
Ccc__7_t5 \$7 t5 1.0412e-17
* device instance cc__7_t6 r0 *1 0,0
Ccc__7_t6 \$7 t6 1.0412e-17
* device instance cc__7_t7 r0 *1 0,0
Ccc__7_t7 \$7 t7 1.0412e-17
* device instance cc__7_vdd r0 *1 0,0
Ccc__7_vdd \$7 vdd 8.3299e-17
* device instance cc__7_vss r0 *1 0,0
Ccc__7_vss \$7 vss 5.2062e-17
* device instance cc__8__9 r0 *1 0,0
Ccc__8__9 \$8 \$9 4.1649e-17
* device instance cc__8_t0 r0 *1 0,0
Ccc__8_t0 \$8 t0 2.0825e-17
* device instance cc__8_t1 r0 *1 0,0
Ccc__8_t1 \$8 t1 2.0825e-17
* device instance cc__8_t2 r0 *1 0,0
Ccc__8_t2 \$8 t2 2.0825e-17
* device instance cc__8_t3 r0 *1 0,0
Ccc__8_t3 \$8 t3 2.0825e-17
* device instance cc__8_t4 r0 *1 0,0
Ccc__8_t4 \$8 t4 2.0825e-17
* device instance cc__8_t5 r0 *1 0,0
Ccc__8_t5 \$8 t5 2.0825e-17
* device instance cc__8_t6 r0 *1 0,0
Ccc__8_t6 \$8 t6 2.0825e-17
* device instance cc__8_t7 r0 *1 0,0
Ccc__8_t7 \$8 t7 2.0825e-17
* device instance cc__8_vss r0 *1 0,0
Ccc__8_vss \$8 vss 8.3299e-17
* device instance cc__9_t0 r0 *1 0,0
Ccc__9_t0 \$9 t0 2.0825e-17
* device instance cc__9_t1 r0 *1 0,0
Ccc__9_t1 \$9 t1 2.0825e-17
* device instance cc__9_t2 r0 *1 0,0
Ccc__9_t2 \$9 t2 2.0825e-17
* device instance cc__9_t3 r0 *1 0,0
Ccc__9_t3 \$9 t3 2.0825e-17
* device instance cc__9_t4 r0 *1 0,0
Ccc__9_t4 \$9 t4 2.0825e-17
* device instance cc__9_t5 r0 *1 0,0
Ccc__9_t5 \$9 t5 2.0825e-17
* device instance cc__9_t6 r0 *1 0,0
Ccc__9_t6 \$9 t6 2.0825e-17
* device instance cc__9_t7 r0 *1 0,0
Ccc__9_t7 \$9 t7 2.0825e-17
* device instance cc__9_vss r0 *1 0,0
Ccc__9_vss \$9 vss 8.3299e-17
* device instance cc_clk_vdd r0 *1 0,0
Ccc_clk_vdd clk vdd 3.1237e-17
* device instance cc_clk_vss r0 *1 0,0
Ccc_clk_vss clk vss 5.2062e-17
* device instance cc_t0_t1 r0 *1 0,0
Ccc_t0_t1 t0 t1 2.0825e-17
* device instance cc_t0_t2 r0 *1 0,0
Ccc_t0_t2 t0 t2 2.0825e-17
* device instance cc_t0_t3 r0 *1 0,0
Ccc_t0_t3 t0 t3 2.0825e-17
* device instance cc_t0_t4 r0 *1 0,0
Ccc_t0_t4 t0 t4 2.0825e-17
* device instance cc_t0_t5 r0 *1 0,0
Ccc_t0_t5 t0 t5 2.0825e-17
* device instance cc_t0_t6 r0 *1 0,0
Ccc_t0_t6 t0 t6 2.0825e-17
* device instance cc_t0_t7 r0 *1 0,0
Ccc_t0_t7 t0 t7 2.0825e-17
* device instance cc_t0_vdd r0 *1 0,0
Ccc_t0_vdd t0 vdd 2.0825e-17
* device instance cc_t0_vss r0 *1 0,0
Ccc_t0_vss t0 vss 9.3711e-17
* device instance cc_t1_t2 r0 *1 0,0
Ccc_t1_t2 t1 t2 2.0825e-17
* device instance cc_t1_t3 r0 *1 0,0
Ccc_t1_t3 t1 t3 2.0825e-17
* device instance cc_t1_t4 r0 *1 0,0
Ccc_t1_t4 t1 t4 2.0825e-17
* device instance cc_t1_t5 r0 *1 0,0
Ccc_t1_t5 t1 t5 2.0825e-17
* device instance cc_t1_t6 r0 *1 0,0
Ccc_t1_t6 t1 t6 2.0825e-17
* device instance cc_t1_t7 r0 *1 0,0
Ccc_t1_t7 t1 t7 2.0825e-17
* device instance cc_t1_vdd r0 *1 0,0
Ccc_t1_vdd t1 vdd 3.1237e-17
* device instance cc_t1_vss r0 *1 0,0
Ccc_t1_vss t1 vss 9.3711e-17
* device instance cc_t2_t3 r0 *1 0,0
Ccc_t2_t3 t2 t3 2.0825e-17
* device instance cc_t2_t4 r0 *1 0,0
Ccc_t2_t4 t2 t4 2.0825e-17
* device instance cc_t2_t5 r0 *1 0,0
Ccc_t2_t5 t2 t5 2.0825e-17
* device instance cc_t2_t6 r0 *1 0,0
Ccc_t2_t6 t2 t6 2.0825e-17
* device instance cc_t2_t7 r0 *1 0,0
Ccc_t2_t7 t2 t7 2.0825e-17
* device instance cc_t2_vdd r0 *1 0,0
Ccc_t2_vdd t2 vdd 4.1649e-17
* device instance cc_t2_vss r0 *1 0,0
Ccc_t2_vss t2 vss 8.3299e-17
* device instance cc_t3_t4 r0 *1 0,0
Ccc_t3_t4 t3 t4 2.0825e-17
* device instance cc_t3_t5 r0 *1 0,0
Ccc_t3_t5 t3 t5 2.0825e-17
* device instance cc_t3_t6 r0 *1 0,0
Ccc_t3_t6 t3 t6 2.0825e-17
* device instance cc_t3_t7 r0 *1 0,0
Ccc_t3_t7 t3 t7 2.0825e-17
* device instance cc_t3_vdd r0 *1 0,0
Ccc_t3_vdd t3 vdd 5.2062e-17
* device instance cc_t3_vss r0 *1 0,0
Ccc_t3_vss t3 vss 7.2887e-17
* device instance cc_t4_t5 r0 *1 0,0
Ccc_t4_t5 t4 t5 2.0825e-17
* device instance cc_t4_t6 r0 *1 0,0
Ccc_t4_t6 t4 t6 2.0825e-17
* device instance cc_t4_t7 r0 *1 0,0
Ccc_t4_t7 t4 t7 2.0825e-17
* device instance cc_t4_vdd r0 *1 0,0
Ccc_t4_vdd t4 vdd 6.2474e-17
* device instance cc_t4_vss r0 *1 0,0
Ccc_t4_vss t4 vss 6.2474e-17
* device instance cc_t5_t6 r0 *1 0,0
Ccc_t5_t6 t5 t6 2.0825e-17
* device instance cc_t5_t7 r0 *1 0,0
Ccc_t5_t7 t5 t7 2.0825e-17
* device instance cc_t5_vdd r0 *1 0,0
Ccc_t5_vdd t5 vdd 7.2887e-17
* device instance cc_t5_vss r0 *1 0,0
Ccc_t5_vss t5 vss 5.2062e-17
* device instance cc_t6_t7 r0 *1 0,0
Ccc_t6_t7 t6 t7 2.0825e-17
* device instance cc_t6_vdd r0 *1 0,0
Ccc_t6_vdd t6 vdd 8.3299e-17
* device instance cc_t6_vss r0 *1 0,0
Ccc_t6_vss t6 vss 4.1649e-17
* device instance cc_t7_vdd r0 *1 0,0
Ccc_t7_vdd t7 vdd 9.3711e-17
* device instance cc_t7_vss r0 *1 0,0
Ccc_t7_vss t7 vss 3.1237e-17
* device instance cc_vdd_vss r0 *1 0,0
Ccc_vdd_vss vdd vss 1.35361e-16
* device instance vsubs_dctie r0 *1 0,0
Rvsubs_dctie vsubs 0 1e+12
.ENDS rcosc_top
XXDUT vdd 0 clk t0 t1 t2 t3 t4 t5 t6 t7 rcosc_top
VDD vdd 0 DC 3.3
VT0 t0 0 DC 0
VT1 t1 0 DC 0
VT2 t2 0 DC 0
VT3 t3 0 DC 0
VT4 t4 0 DC 0
VT5 t5 0 DC 0
VT6 t6 0 DC 0
VT7 t7 0 DC 0
* supply-current integrator (analysis only): v(qint) = integral of -i(VDD) dt / 1 nF
Bint 0 qint I=-i(VDD)
Cint qint 0 1n
Rint qint 0 1e15
.ic v(qint)=0
.control
set noaskquit
set measureprec=8
setplot new
set sp = $curplot
let cclamp = 166
  option temp = -40
  alter vdd = 3
  let vb = 3 * (floor(cclamp / 1) - 2 * floor(cclamp / 2))
  alter vt0 = $&vb
  let vb = 3 * (floor(cclamp / 2) - 2 * floor(cclamp / 4))
  alter vt1 = $&vb
  let vb = 3 * (floor(cclamp / 4) - 2 * floor(cclamp / 8))
  alter vt2 = $&vb
  let vb = 3 * (floor(cclamp / 8) - 2 * floor(cclamp / 16))
  alter vt3 = $&vb
  let vb = 3 * (floor(cclamp / 16) - 2 * floor(cclamp / 32))
  alter vt4 = $&vb
  let vb = 3 * (floor(cclamp / 32) - 2 * floor(cclamp / 64))
  alter vt5 = $&vb
  let vb = 3 * (floor(cclamp / 64) - 2 * floor(cclamp / 128))
  alter vt6 = $&vb
  let vb = 3 * (floor(cclamp / 128) - 2 * floor(cclamp / 256))
  alter vt7 = $&vb
  tran 200p 4000n
  meas tran ta when v(clk)=1.5000 rise=5
  meas tran tb when v(clk)=1.5000 rise=25
  meas tran qa find v(qint) when v(clk)=1.5000 rise=5
  meas tran qb find v(qint) when v(clk)=1.5000 rise=25
  let fx = 20 / (tb - ta)
  let iqx = (qb - qa) * 1e-9 / (tb - ta)
  set fs = $&fx
  set iqs = $&iqx
  setplot $sp
  let f_n40_30 = $fs
  let iq_n40_30 = $iqs
  option temp = -40
  alter vdd = 3.3
  let vb = 3.3 * (floor(cclamp / 1) - 2 * floor(cclamp / 2))
  alter vt0 = $&vb
  let vb = 3.3 * (floor(cclamp / 2) - 2 * floor(cclamp / 4))
  alter vt1 = $&vb
  let vb = 3.3 * (floor(cclamp / 4) - 2 * floor(cclamp / 8))
  alter vt2 = $&vb
  let vb = 3.3 * (floor(cclamp / 8) - 2 * floor(cclamp / 16))
  alter vt3 = $&vb
  let vb = 3.3 * (floor(cclamp / 16) - 2 * floor(cclamp / 32))
  alter vt4 = $&vb
  let vb = 3.3 * (floor(cclamp / 32) - 2 * floor(cclamp / 64))
  alter vt5 = $&vb
  let vb = 3.3 * (floor(cclamp / 64) - 2 * floor(cclamp / 128))
  alter vt6 = $&vb
  let vb = 3.3 * (floor(cclamp / 128) - 2 * floor(cclamp / 256))
  alter vt7 = $&vb
  tran 200p 4000n
  meas tran ta when v(clk)=1.6500 rise=5
  meas tran tb when v(clk)=1.6500 rise=25
  meas tran qa find v(qint) when v(clk)=1.6500 rise=5
  meas tran qb find v(qint) when v(clk)=1.6500 rise=25
  let fx = 20 / (tb - ta)
  let iqx = (qb - qa) * 1e-9 / (tb - ta)
  set fs = $&fx
  set iqs = $&iqx
  setplot $sp
  let f_n40_33 = $fs
  let iq_n40_33 = $iqs
  option temp = -40
  alter vdd = 3.6
  let vb = 3.6 * (floor(cclamp / 1) - 2 * floor(cclamp / 2))
  alter vt0 = $&vb
  let vb = 3.6 * (floor(cclamp / 2) - 2 * floor(cclamp / 4))
  alter vt1 = $&vb
  let vb = 3.6 * (floor(cclamp / 4) - 2 * floor(cclamp / 8))
  alter vt2 = $&vb
  let vb = 3.6 * (floor(cclamp / 8) - 2 * floor(cclamp / 16))
  alter vt3 = $&vb
  let vb = 3.6 * (floor(cclamp / 16) - 2 * floor(cclamp / 32))
  alter vt4 = $&vb
  let vb = 3.6 * (floor(cclamp / 32) - 2 * floor(cclamp / 64))
  alter vt5 = $&vb
  let vb = 3.6 * (floor(cclamp / 64) - 2 * floor(cclamp / 128))
  alter vt6 = $&vb
  let vb = 3.6 * (floor(cclamp / 128) - 2 * floor(cclamp / 256))
  alter vt7 = $&vb
  tran 200p 4000n
  meas tran ta when v(clk)=1.8000 rise=5
  meas tran tb when v(clk)=1.8000 rise=25
  meas tran qa find v(qint) when v(clk)=1.8000 rise=5
  meas tran qb find v(qint) when v(clk)=1.8000 rise=25
  let fx = 20 / (tb - ta)
  let iqx = (qb - qa) * 1e-9 / (tb - ta)
  set fs = $&fx
  set iqs = $&iqx
  setplot $sp
  let f_n40_36 = $fs
  let iq_n40_36 = $iqs
  option temp = 27
  alter vdd = 3
  let vb = 3 * (floor(cclamp / 1) - 2 * floor(cclamp / 2))
  alter vt0 = $&vb
  let vb = 3 * (floor(cclamp / 2) - 2 * floor(cclamp / 4))
  alter vt1 = $&vb
  let vb = 3 * (floor(cclamp / 4) - 2 * floor(cclamp / 8))
  alter vt2 = $&vb
  let vb = 3 * (floor(cclamp / 8) - 2 * floor(cclamp / 16))
  alter vt3 = $&vb
  let vb = 3 * (floor(cclamp / 16) - 2 * floor(cclamp / 32))
  alter vt4 = $&vb
  let vb = 3 * (floor(cclamp / 32) - 2 * floor(cclamp / 64))
  alter vt5 = $&vb
  let vb = 3 * (floor(cclamp / 64) - 2 * floor(cclamp / 128))
  alter vt6 = $&vb
  let vb = 3 * (floor(cclamp / 128) - 2 * floor(cclamp / 256))
  alter vt7 = $&vb
  tran 200p 4000n
  meas tran ta when v(clk)=1.5000 rise=5
  meas tran tb when v(clk)=1.5000 rise=25
  meas tran qa find v(qint) when v(clk)=1.5000 rise=5
  meas tran qb find v(qint) when v(clk)=1.5000 rise=25
  let fx = 20 / (tb - ta)
  let iqx = (qb - qa) * 1e-9 / (tb - ta)
  set fs = $&fx
  set iqs = $&iqx
  setplot $sp
  let f_27_30 = $fs
  let iq_27_30 = $iqs
  option temp = 27
  alter vdd = 3.3
  let vb = 3.3 * (floor(cclamp / 1) - 2 * floor(cclamp / 2))
  alter vt0 = $&vb
  let vb = 3.3 * (floor(cclamp / 2) - 2 * floor(cclamp / 4))
  alter vt1 = $&vb
  let vb = 3.3 * (floor(cclamp / 4) - 2 * floor(cclamp / 8))
  alter vt2 = $&vb
  let vb = 3.3 * (floor(cclamp / 8) - 2 * floor(cclamp / 16))
  alter vt3 = $&vb
  let vb = 3.3 * (floor(cclamp / 16) - 2 * floor(cclamp / 32))
  alter vt4 = $&vb
  let vb = 3.3 * (floor(cclamp / 32) - 2 * floor(cclamp / 64))
  alter vt5 = $&vb
  let vb = 3.3 * (floor(cclamp / 64) - 2 * floor(cclamp / 128))
  alter vt6 = $&vb
  let vb = 3.3 * (floor(cclamp / 128) - 2 * floor(cclamp / 256))
  alter vt7 = $&vb
  tran 200p 4000n
  meas tran ta when v(clk)=1.6500 rise=5
  meas tran tb when v(clk)=1.6500 rise=25
  meas tran qa find v(qint) when v(clk)=1.6500 rise=5
  meas tran qb find v(qint) when v(clk)=1.6500 rise=25
  let fx = 20 / (tb - ta)
  let iqx = (qb - qa) * 1e-9 / (tb - ta)
  set fs = $&fx
  set iqs = $&iqx
  setplot $sp
  let f_27_33 = $fs
  let iq_27_33 = $iqs
  option temp = 27
  alter vdd = 3.6
  let vb = 3.6 * (floor(cclamp / 1) - 2 * floor(cclamp / 2))
  alter vt0 = $&vb
  let vb = 3.6 * (floor(cclamp / 2) - 2 * floor(cclamp / 4))
  alter vt1 = $&vb
  let vb = 3.6 * (floor(cclamp / 4) - 2 * floor(cclamp / 8))
  alter vt2 = $&vb
  let vb = 3.6 * (floor(cclamp / 8) - 2 * floor(cclamp / 16))
  alter vt3 = $&vb
  let vb = 3.6 * (floor(cclamp / 16) - 2 * floor(cclamp / 32))
  alter vt4 = $&vb
  let vb = 3.6 * (floor(cclamp / 32) - 2 * floor(cclamp / 64))
  alter vt5 = $&vb
  let vb = 3.6 * (floor(cclamp / 64) - 2 * floor(cclamp / 128))
  alter vt6 = $&vb
  let vb = 3.6 * (floor(cclamp / 128) - 2 * floor(cclamp / 256))
  alter vt7 = $&vb
  tran 200p 4000n
  meas tran ta when v(clk)=1.8000 rise=5
  meas tran tb when v(clk)=1.8000 rise=25
  meas tran qa find v(qint) when v(clk)=1.8000 rise=5
  meas tran qb find v(qint) when v(clk)=1.8000 rise=25
  let fx = 20 / (tb - ta)
  let iqx = (qb - qa) * 1e-9 / (tb - ta)
  set fs = $&fx
  set iqs = $&iqx
  setplot $sp
  let f_27_36 = $fs
  let iq_27_36 = $iqs
  option temp = 85
  alter vdd = 3
  let vb = 3 * (floor(cclamp / 1) - 2 * floor(cclamp / 2))
  alter vt0 = $&vb
  let vb = 3 * (floor(cclamp / 2) - 2 * floor(cclamp / 4))
  alter vt1 = $&vb
  let vb = 3 * (floor(cclamp / 4) - 2 * floor(cclamp / 8))
  alter vt2 = $&vb
  let vb = 3 * (floor(cclamp / 8) - 2 * floor(cclamp / 16))
  alter vt3 = $&vb
  let vb = 3 * (floor(cclamp / 16) - 2 * floor(cclamp / 32))
  alter vt4 = $&vb
  let vb = 3 * (floor(cclamp / 32) - 2 * floor(cclamp / 64))
  alter vt5 = $&vb
  let vb = 3 * (floor(cclamp / 64) - 2 * floor(cclamp / 128))
  alter vt6 = $&vb
  let vb = 3 * (floor(cclamp / 128) - 2 * floor(cclamp / 256))
  alter vt7 = $&vb
  tran 200p 4000n
  meas tran ta when v(clk)=1.5000 rise=5
  meas tran tb when v(clk)=1.5000 rise=25
  meas tran qa find v(qint) when v(clk)=1.5000 rise=5
  meas tran qb find v(qint) when v(clk)=1.5000 rise=25
  let fx = 20 / (tb - ta)
  let iqx = (qb - qa) * 1e-9 / (tb - ta)
  set fs = $&fx
  set iqs = $&iqx
  setplot $sp
  let f_85_30 = $fs
  let iq_85_30 = $iqs
  option temp = 85
  alter vdd = 3.3
  let vb = 3.3 * (floor(cclamp / 1) - 2 * floor(cclamp / 2))
  alter vt0 = $&vb
  let vb = 3.3 * (floor(cclamp / 2) - 2 * floor(cclamp / 4))
  alter vt1 = $&vb
  let vb = 3.3 * (floor(cclamp / 4) - 2 * floor(cclamp / 8))
  alter vt2 = $&vb
  let vb = 3.3 * (floor(cclamp / 8) - 2 * floor(cclamp / 16))
  alter vt3 = $&vb
  let vb = 3.3 * (floor(cclamp / 16) - 2 * floor(cclamp / 32))
  alter vt4 = $&vb
  let vb = 3.3 * (floor(cclamp / 32) - 2 * floor(cclamp / 64))
  alter vt5 = $&vb
  let vb = 3.3 * (floor(cclamp / 64) - 2 * floor(cclamp / 128))
  alter vt6 = $&vb
  let vb = 3.3 * (floor(cclamp / 128) - 2 * floor(cclamp / 256))
  alter vt7 = $&vb
  tran 200p 4000n
  meas tran ta when v(clk)=1.6500 rise=5
  meas tran tb when v(clk)=1.6500 rise=25
  meas tran qa find v(qint) when v(clk)=1.6500 rise=5
  meas tran qb find v(qint) when v(clk)=1.6500 rise=25
  let fx = 20 / (tb - ta)
  let iqx = (qb - qa) * 1e-9 / (tb - ta)
  set fs = $&fx
  set iqs = $&iqx
  setplot $sp
  let f_85_33 = $fs
  let iq_85_33 = $iqs
  option temp = 85
  alter vdd = 3.6
  let vb = 3.6 * (floor(cclamp / 1) - 2 * floor(cclamp / 2))
  alter vt0 = $&vb
  let vb = 3.6 * (floor(cclamp / 2) - 2 * floor(cclamp / 4))
  alter vt1 = $&vb
  let vb = 3.6 * (floor(cclamp / 4) - 2 * floor(cclamp / 8))
  alter vt2 = $&vb
  let vb = 3.6 * (floor(cclamp / 8) - 2 * floor(cclamp / 16))
  alter vt3 = $&vb
  let vb = 3.6 * (floor(cclamp / 16) - 2 * floor(cclamp / 32))
  alter vt4 = $&vb
  let vb = 3.6 * (floor(cclamp / 32) - 2 * floor(cclamp / 64))
  alter vt5 = $&vb
  let vb = 3.6 * (floor(cclamp / 64) - 2 * floor(cclamp / 128))
  alter vt6 = $&vb
  let vb = 3.6 * (floor(cclamp / 128) - 2 * floor(cclamp / 256))
  alter vt7 = $&vb
  tran 200p 4000n
  meas tran ta when v(clk)=1.8000 rise=5
  meas tran tb when v(clk)=1.8000 rise=25
  meas tran qa find v(qint) when v(clk)=1.8000 rise=5
  meas tran qb find v(qint) when v(clk)=1.8000 rise=25
  let fx = 20 / (tb - ta)
  let iqx = (qb - qa) * 1e-9 / (tb - ta)
  set fs = $&fx
  set iqs = $&iqx
  setplot $sp
  let f_85_36 = $fs
  let iq_85_36 = $iqs
set v_code = $&cclamp
set v_f_n40_30 = $&f_n40_30
set v_iq_n40_30 = $&iq_n40_30
set v_f_n40_33 = $&f_n40_33
set v_iq_n40_33 = $&iq_n40_33
set v_f_n40_36 = $&f_n40_36
set v_iq_n40_36 = $&iq_n40_36
set v_f_27_30 = $&f_27_30
set v_iq_27_30 = $&iq_27_30
set v_f_27_33 = $&f_27_33
set v_iq_27_33 = $&iq_27_33
set v_f_27_36 = $&f_27_36
set v_iq_27_36 = $&iq_27_36
set v_f_85_30 = $&f_85_30
set v_iq_85_30 = $&iq_85_30
set v_f_85_33 = $&f_85_33
set v_iq_85_33 = $&iq_85_33
set v_f_85_36 = $&f_85_36
set v_iq_85_36 = $&iq_85_36
wrdata meas.csv f_n40_30 f_n40_33 f_n40_36 f_27_30 f_27_33 f_27_36 f_85_30 f_85_33 f_85_36 iq_n40_30 iq_n40_33 iq_n40_36 iq_27_30 iq_27_33 iq_27_36 iq_85_30 iq_85_33 iq_85_36
.endc
