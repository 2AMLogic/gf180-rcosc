* libpath probe: $PDK_ROOT/libs.tech/ngspice/sm141064.ngspice
.lib $PDK_ROOT/libs.tech/ngspice/sm141064.ngspice typical
.end
