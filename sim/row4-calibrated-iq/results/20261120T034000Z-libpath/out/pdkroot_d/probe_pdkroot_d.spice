* libpath probe: $PDK_ROOT/gf180mcuD/libs.tech/ngspice/sm141064.ngspice
.lib $PDK_ROOT/gf180mcuD/libs.tech/ngspice/sm141064.ngspice typical
.end
