* libpath probe: $PDK_ROOT/gf180mcuD/libs.tech/ngspice/sm141064.ngspice
.lib /opt/pdk/gf180mcuD/libs.tech/ngspice/sm141064.ngspice typical
.end
