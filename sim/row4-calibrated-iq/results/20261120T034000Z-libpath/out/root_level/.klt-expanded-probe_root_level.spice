* libpath probe: $PDK_ROOT/sm141064.ngspice
.lib /opt/pdk/sm141064.ngspice typical
.end
