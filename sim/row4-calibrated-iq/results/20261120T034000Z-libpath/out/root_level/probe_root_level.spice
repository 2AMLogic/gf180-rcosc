* libpath probe: $PDK_ROOT/sm141064.ngspice
.lib $PDK_ROOT/sm141064.ngspice typical
.end
