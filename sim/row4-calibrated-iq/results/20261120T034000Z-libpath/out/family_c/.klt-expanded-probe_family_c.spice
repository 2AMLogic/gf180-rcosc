* libpath probe: $PDK_ROOT/gf180mcu/gf180mcuC/libs.tech/ngspice/sm141064.ngspice
.lib /opt/pdk/gf180mcu/gf180mcuC/libs.tech/ngspice/sm141064.ngspice typical
.end
