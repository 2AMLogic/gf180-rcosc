* libpath probe: $PDK_ROOT/gf180mcuC/ngspice/sm141064.ngspice
.lib /opt/pdk/gf180mcuC/ngspice/sm141064.ngspice typical
.end
