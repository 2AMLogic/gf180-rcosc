* libpath probe: $PDK_ROOT/libs.tech/ngspice/sm141064.ngspice
.lib /opt/pdk/libs.tech/ngspice/sm141064.ngspice typical
.end
