* klt sim -- generated corner deck, do not edit
.lib /opt/pdk/gf180mcuC/libs.tech/ngspice/sm141064.ngspice typical
.lib /opt/pdk/gf180mcuC/libs.tech/ngspice/sm141064.ngspice res_typical
.lib /opt/pdk/gf180mcuC/libs.tech/ngspice/sm141064.ngspice mimcap_typical
.lib /opt/pdk/gf180mcuC/libs.tech/ngspice/sm141064.ngspice cap_mim
.include /var/tmp/eda-job-klt-sim-58ef1d67a0ce/inputs/netlist.cir
.temp 85.0
.meas tran t_first_edge WHEN v(clk)=1.6500 RISE=1
.meas tran t_edge_50 WHEN v(clk)=1.6500 RISE=50
.control
set filetype=ascii
tran 200p 20000n
write /var/tmp/eda-job-klt-sim-58ef1d67a0ce/outputs/artifacts/tt_novdd_85C/waveform.raw
quit
.endc
.end
