* probe ramp_ctl_fs_m40_v30: fs / -40 C / 3 V, code 0xA9 (gen_probes.py, issue #227)
.param sw_stat_global=0 sw_stat_mismatch=0 mc_skew=3 res_mc_skew=3 cap_mc_skew=3 fnoicor=0
.include "rcosc_top_p3.spice"
XXDUT vdd 0 clk t0 t1 t2 t3 t4 t5 t6 t7 rcosc_top
VDD vdd 0 PWL(0 0 1000n 3)
BIQ iq_ua 0 V=-1e6*i(VDD)
VT0 t0 0 PWL(0 0 1000n 3)
VT1 t1 0 DC 0
VT2 t2 0 DC 0
VT3 t3 0 PWL(0 0 1000n 3)
VT4 t4 0 DC 0
VT5 t5 0 PWL(0 0 1000n 3)
VT6 t6 0 DC 0
VT7 t7 0 PWL(0 0 1000n 3)
.save v(clk) v(vdd) v(xxdut.\$26) v(xxdut.\$7) v(xxdut.\$29) v(xxdut.\$30) v(xxdut.\$31) v(xxdut.\$32) v(xxdut.\$36) v(xxdut.\$35) v(xxdut.\$37)
