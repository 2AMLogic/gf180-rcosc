* klt sim -- generated corner deck, do not edit
.lib /opt/pdk/gf180mcuC/libs.tech/ngspice/sm141064.ngspice typical
.lib /opt/pdk/gf180mcuC/libs.tech/ngspice/sm141064.ngspice res_ff
.lib /opt/pdk/gf180mcuC/libs.tech/ngspice/sm141064.ngspice mimcap_ff
.lib /opt/pdk/gf180mcuC/libs.tech/ngspice/sm141064.ngspice cap_mim
.include /var/tmp/eda-job-klt-sim-26f2d42d72d7/inputs/netlist.cir
.temp 85.0
.meas tran ta WHEN v(clk)=1.8000 RISE=5
.meas tran tb WHEN v(clk)=1.8000 RISE=25
.meas tran fosc PARAM='20/(tb-ta)'
.meas tran iq_run_ua AVG v(iq_ua) FROM=200n TO=1200n
.control
save all
tran 200p 1200n
quit
.endc
.end
