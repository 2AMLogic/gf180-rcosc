* klt sim -- generated corner deck, do not edit
.lib /opt/pdk/gf180mcuC/libs.tech/ngspice/sm141064.ngspice typical
.lib /opt/pdk/gf180mcuC/libs.tech/ngspice/sm141064.ngspice res_ss
.lib /opt/pdk/gf180mcuC/libs.tech/ngspice/sm141064.ngspice mimcap_ss
.lib /opt/pdk/gf180mcuC/libs.tech/ngspice/sm141064.ngspice cap_mim
.include /var/tmp/eda-job-klt-sim-7568c162dd9f/inputs/netlist.cir
.temp -40.0
.meas tran ta WHEN v(clk)=1.6500 RISE=5
.meas tran tb WHEN v(clk)=1.6500 RISE=25
.meas tran fosc PARAM='20/(tb-ta)'
.meas tran iq_run_ua AVG v(iq_ua) FROM=200n TO=1200n
.control
save all
tran 200p 1200n
quit
.endc
.end
