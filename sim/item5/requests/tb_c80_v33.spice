* rcosc_top item-5 corner bench, VDD=3.3 V, trim code 0x80 (generated by gen_requests.py)
.param sw_stat_global=0 sw_stat_mismatch=0 mc_skew=3 res_mc_skew=3 cap_mc_skew=3 fnoicor=0
.include "rcosc_top_schematic.spice"
XXDUT vdd 0 clk t0 t1 t2 t3 t4 t5 t6 t7 rcosc_top
VDD vdd 0 DC 3.3
BIQ iq_ua 0 V=-1e6*i(VDD)
VT0 t0 0 DC 0
VT1 t1 0 DC 0
VT2 t2 0 DC 0
VT3 t3 0 DC 0
VT4 t4 0 DC 0
VT5 t5 0 DC 0
VT6 t6 0 DC 0
VT7 t7 0 DC 3.3
