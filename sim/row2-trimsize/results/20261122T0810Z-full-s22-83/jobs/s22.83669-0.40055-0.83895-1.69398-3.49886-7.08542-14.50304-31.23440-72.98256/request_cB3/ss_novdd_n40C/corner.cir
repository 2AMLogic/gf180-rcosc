* klt sim -- generated corner deck, do not edit
.lib /opt/pdk/gf180mcuC/libs.tech/ngspice/sm141064.ngspice ss
.lib /opt/pdk/gf180mcuC/libs.tech/ngspice/sm141064.ngspice res_ss
.lib /opt/pdk/gf180mcuC/libs.tech/ngspice/sm141064.ngspice mimcap_ss
.lib /opt/pdk/gf180mcuC/libs.tech/ngspice/sm141064.ngspice cap_mim
.include /var/tmp/eda-job-klt-sim-a9c7bf9088e2/inputs/netlist.cir
.temp -40.0
.meas tran ta WHEN v(clk)=1.5000 RISE=5
.meas tran tb WHEN v(clk)=1.5000 RISE=25
.meas tran fosc PARAM='20/(tb-ta)'
.control
save all
tran 200p 2000n
quit
.endc
.end
