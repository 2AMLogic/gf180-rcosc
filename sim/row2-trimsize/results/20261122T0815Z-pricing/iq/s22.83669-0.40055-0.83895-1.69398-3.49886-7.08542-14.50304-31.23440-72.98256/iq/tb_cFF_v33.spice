* row2-trimsize pricing bench, code 0xFF, VDD=3.3 V (generated by gen_pricing.py)
.param sw_stat_global=0 sw_stat_mismatch=0 mc_skew=3 res_mc_skew=3 cap_mc_skew=3 fnoicor=0
.include "rcosc_top_variant.spice"
XXDUT vdd 0 clk t0 t1 t2 t3 t4 t5 t6 t7 rcosc_top
VDD vdd 0 DC 3.3
VT0 t0 0 DC 3.3
VT1 t1 0 DC 3.3
VT2 t2 0 DC 3.3
VT3 t3 0 DC 3.3
VT4 t4 0 DC 3.3
VT5 t5 0 DC 3.3
VT6 t6 0 DC 3.3
VT7 t7 0 DC 3.3
* supply-current integrator (analysis only): v(qint) = integral of -i(VDD) dt / 1 nF
Bint 0 qint I=-i(VDD)
Cint qint 0 1n
Rint qint 0 1e15
.ic v(qint)=0
