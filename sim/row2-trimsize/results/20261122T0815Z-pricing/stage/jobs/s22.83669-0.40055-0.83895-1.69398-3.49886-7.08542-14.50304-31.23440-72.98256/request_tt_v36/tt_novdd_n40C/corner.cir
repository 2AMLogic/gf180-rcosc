* klt sim -- generated corner deck, do not edit
.lib /opt/pdk/gf180mcuC/libs.tech/ngspice/sm141064.ngspice typical
.lib /opt/pdk/gf180mcuC/libs.tech/ngspice/sm141064.ngspice res_typical
.lib /opt/pdk/gf180mcuC/libs.tech/ngspice/sm141064.ngspice mimcap_typical
.lib /opt/pdk/gf180mcuC/libs.tech/ngspice/sm141064.ngspice cap_mim
.include /var/tmp/eda-job-klt-sim-922b871557fd/inputs/netlist.cir
.temp -40.0
.meas tran f_ta WHEN v(clk)=1.8000 RISE=5
.meas tran f_tb WHEN v(clk)=1.8000 RISE=25
.meas tran fosc PARAM='20/(f_tb-f_ta)'
.control
save all
tran 200p 1200n
quit
.endc
.end
