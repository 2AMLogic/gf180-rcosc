* rcosc_top dense-trim bench (screen), VDD=3.3 V, trim code 0xFF (generated by sim/trim-dense/prepare.py; NOT evidence)
.param sw_stat_global=0 sw_stat_mismatch=0 mc_skew=3 res_mc_skew=3 cap_mc_skew=3 fnoicor=0
.options reltol=0.001 abstol=1e-12 vntol=1e-06
.include "rcosc_top_s30.87078-0.18093-0.45059-0.97650-2.08666-4.29269-8.85515-19.14635-44.82498w2.spice"
XXDUT vdd 0 clk t0 t1 t2 t3 t4 t5 t6 t7 rcosc_top
VDD vdd 0 DC 3.3
VT0 t0 0 DC 3.3
VT1 t1 0 DC 3.3
VT2 t2 0 DC 3.3
VT3 t3 0 DC 3.3
VT4 t4 0 DC 3.3
VT5 t5 0 DC 3.3
VT6 t6 0 DC 3.3
VT7 t7 0 DC 3.3
