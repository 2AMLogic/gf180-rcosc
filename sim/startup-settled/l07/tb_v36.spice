* rcosc_top settled-netlist startup bench, VDD ramp 0->3.6 V in 1000 ns, trim 0xA4 (gen_requests.py)
.param sw_stat_global=0 sw_stat_mismatch=0 mc_skew=3 res_mc_skew=3 cap_mc_skew=3 fnoicor=0
.include "rcosc_top_p3.spice"
XXDUT vdd 0 clk t0 t1 t2 t3 t4 t5 t6 t7 rcosc_top
VDD vdd 0 PWL(0 0 1000n 3.6)
VT0 t0 0 DC 0
VT1 t1 0 DC 0
VT2 t2 0 PWL(0 0 1000n 3.6)
VT3 t3 0 DC 0
VT4 t4 0 DC 0
VT5 t5 0 PWL(0 0 1000n 3.6)
VT6 t6 0 DC 0
VT7 t7 0 PWL(0 0 1000n 3.6)
.save v(clk) v(vdd)
