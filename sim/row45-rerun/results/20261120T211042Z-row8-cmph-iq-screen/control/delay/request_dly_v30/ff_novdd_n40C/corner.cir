* klt sim -- generated corner deck, do not edit
.lib /opt/pdk/gf180mcuC/libs.tech/ngspice/sm141064.ngspice ff
.lib /opt/pdk/gf180mcuC/libs.tech/ngspice/sm141064.ngspice res_ff
.lib /opt/pdk/gf180mcuC/libs.tech/ngspice/sm141064.ngspice mimcap_ff
.lib /opt/pdk/gf180mcuC/libs.tech/ngspice/sm141064.ngspice cap_mim
.include /var/tmp/eda-job-klt-sim-68c6bdecd9f5/inputs/netlist.cir
.temp -40.0
.meas tran ev_vh WHEN v(pvc)=v(pvh) RISE=1 TD=700n
.meas tran ev_cmph WHEN v(pcmph)=1.5000 RISE=1 TD=700n
.meas tran ev_clk WHEN v(clk)=1.5000 RISE=1 TD=700n
.meas tran vh_avg AVG v(pvh) FROM=900n TO=1200n
.meas tran f_ta WHEN v(clk)=1.5000 RISE=5
.meas tran f_tb WHEN v(clk)=1.5000 RISE=25
.meas tran fosc PARAM='20/(f_tb-f_ta)'
.control
save all
tran 200p 1200n
quit
.endc
.end
