* row-8 t_cmp_h bench, code 0x57, VDD=3.6 V (generated by gen_row8_screen.py, issue #458)
.param sw_stat_global=0 sw_stat_mismatch=0 mc_skew=3 res_mc_skew=3 cap_mc_skew=3 fnoicor=0
.include "rcosc_top_variant.spice"
XXDUT vdd 0 clk t0 t1 t2 t3 t4 t5 t6 t7 pvc pvh pcmph rcosc_top
VDD vdd 0 DC 3.6
VT0 t0 0 DC 3.6
VT1 t1 0 DC 3.6
VT2 t2 0 DC 3.6
VT3 t3 0 DC 0
VT4 t4 0 DC 3.6
VT5 t5 0 DC 0
VT6 t6 0 DC 3.6
VT7 t7 0 DC 0
